** sch_path: /foss/designs/ClockExtractor2026/clock_extractor_tran_2026 .sch
**.subckt clock_extractor_tran_2026
VDD VDD GND 3
VDD1 VDD1 GND 1.2
XM7 vout1 vout net3 net3 sg13_hv_nmos w=1.05u l=0.45u ng=1
XM6 vout1 vout VDD1 VDD1 sg13_hv_pmos w=1.43u l=0.4u ng=1
XM4 net1 net1 VDD VDD sg13_hv_pmos w=2u l=1.5u ng=1
XM1 net7 net1 VDD VDD sg13_hv_pmos w=2u l=1.5u ng=1 m=6
XM2 vout net1 VDD VDD sg13_hv_pmos w=2u l=1.5u ng=1 m=6
XM3 net5 ANT11 net2 VDD sg13_hv_pmos w=4.5u l=1u ng=1 m=2
XM5 net6 ANT22 net2 VDD sg13_hv_pmos w=4.5u l=1u ng=1 m=2
XM10 v2 v1 net3 net3 sg13_hv_nmos w=1.2u l=0.8u ng=1 m=2
XM11 v1 v1 net3 net3 sg13_hv_nmos w=1.2u l=0.8u ng=1 m=2
XM12 net4 v2 net3 net3 sg13_hv_nmos w=1.2u l=0.8u ng=1 m=4
Vmeas net3 GND 0
.save i(vmeas)
Vmeas1 net5 v2 0
.save i(vmeas1)
Vmeas2 net6 v1 0
.save i(vmeas2)
Vmeas3 vout net4 0
.save i(vmeas3)
Vmeas4 net7 net2 0
.save i(vmeas4)
XM27 vclk vout1 VDD2 VDD2 sg13_lv_pmos w=1.12u l=0.13u ng=1
XM29 vclk vout1 net3 net3 sg13_lv_nmos w=0.74u l=0.13u ng=1
VDD2 VDD2 GND 1.2
XM31 net9 net8 net3 net3 sg13_hv_nmos w=3u l=10u ng=1 m=2
XM32 net8 net8 net3 net3 sg13_hv_nmos w=3u l=10u ng=1
Vmeas8 net1 net9 0
.save i(vmeas8)
I0 VDD net8 1u
VIN1 net10 GND sine(0 4.3 13560k 0 0) 1 ac 1

L9 GND net13 0.9u
C2 net12 GND 106.14p
R7 net11 net10 50
C4 net12 net11 48.29p
R8 net13 net12 4.79
L11 net30 net21 5.43u
XR16 ANT11 net21 sub! rsil w=2u l=1.23u m=1 b=0
XR19 ANT22 net30 sub! rsil w=2u l=1.23u m=1 b=0
XC6 ANT11 ANT22 cap_cmim w=40u l=50u
XM8 ANT11 ANT11 net14 net14 sg13_hv_pmos w=w1 l=l1 ng=ng1 m=m1
XM9 net17 net17 net25 net18 sg13_hv_pmos w=w1 l=l1 ng=ng1 m=m1
R20 net27 ANT22 100K
R21 ANT11 net19 100K
XM13 ANT11 ANT11 net22 net28 sg13_hv_nmos w=w2 l=l2 ng=ng1 m=m2
XM14 ANT22 ANT22 net22 net29 sg13_hv_nmos w=w2 l=l2 ng=ng1 m=m2
C11 net23 VSS 1n
R22 net20 VSS 5k
Vmeas12 net19 net18 0
.save i(vmeas12)
C12 ANT11 VSS 46p
C13 VSS ANT22 46p
XM15 ANT11 ANT22 net24 net28 sg13_hv_nmos w=w2 l=l2 ng=ng1 m=m2
XM16 ANT22 ANT11 net24 net29 sg13_hv_nmos w=w2 l=l2 ng=ng1 m=m2
XM17 net14 net14 net15 net15 sg13_hv_pmos w=w1 l=l1 ng=ng1 m=m1
XM18 net15 net15 net26 net27 sg13_hv_pmos w=w1 l=l1 ng=ng1 m=m1
XM19 net16 net16 net17 net17 sg13_hv_pmos w=w1 l=l1 ng=ng1 m=m1
XM20 ANT22 ANT22 net16 net16 sg13_hv_pmos w=w1 l=l1 ng=ng1 m=m1
Vmeas7 Voo net20 0
.save i(vmeas7)
Vmeas9 Voo net23 0
.save i(vmeas9)
Vmeas10 net26 ANT22 0
.save i(vmeas10)
Vmeas11 ANT11 net25 0
.save i(vmeas11)
Vmeas13 net24 VSS 0
.save i(vmeas13)
Vmeas14 net22 Voo 0
.save i(vmeas14)
Vmeas15 net28 net24 0
.save i(vmeas15)
Vmeas16 net29 net24 0
.save i(vmeas16)
R24 VSS net31 1000Meg
VIN2 net31 GND 0
**** begin user architecture code

.lib cornerMOSlv.lib mos_tt
.lib cornerMOShv.lib mos_tt
.lib cornerCAP.lib cap_typ
.lib cornerRES.lib res_typ

.param temp=27
.options rshunt =1e12
.param w1=5u
.param w2=10u
.param l1=0.5u
.param l2=1u
.param ng1=1
.param m1=20
.param m2=10
.param Coef=0.1
.save all
.control
 save all
* Transient simulation
op
tran 50p 12u
plot vclk
//plot vout
//plot vout1
plot i(Vmeas7)
plot i(Vmeas)
//plot vout2
plot Vp-Vn

meas tran avg_current AVG I(VDD)  from=5u to=5.5u
let  power_VDD=3*avg_current
meas tran avg_current_1 AVG I(VDD1) from=5u to=5.5u
let  power_VDD1=1.2*avg_current_1
meas tran avg_current_2 AVG I(VDD2) from=5u to=5.5u
let  power_VDD2=1.2*avg_current_2
let total_power=power_VDD + power_VDD1 + power_VDD2

meas tran thigh TRIG v(vclk) VAL=1.08 RISE=39 TARG v(vclk) VAL=1.08 FALL=39
meas tran tlow TRIG  v(vclk)  VAL=0.12 FALL=39  TARG v(vclk) VAL=0.12 RISE=40

//meas tran thigh TRIG v(vclk) VAl=0.6 RISE=25 TARG v(vclk) VAl=0.6 FALL=25
//meas tran tlow  TRIG v(vclk) VAl=0.6 FALL=25 TARG v(vclk) VAl=0.6 RISE=26
  * rise time and fall time
meas tran t100 when v(vclk)=0.12 rise=25
meas tran t90  when  v(vclk)=1.08 rise=25

let RiseTime = t90 - t100

meas tran t90_f when v(vclk)=1.08 fall=25
meas tran t10_f when v(vclk)=0.12 fall=25

let FallTime = t10_f - t90_f

meas tran t1 when v(vclk)=0.6 rise=25
meas tran t2 when v(vclk)=0.6 rise=26
let period1 =(t2 - t1)
let freq1 =1/period1

meas tran t3 when v(vclk)=0.6 rise=27
let period2 =(t3 - t2)
let freq2 =1/period2

meas tran t4 when v(vclk)=0.6 rise=28
let period3 =(t4 - t3)
let freq3 =1/period3

meas tran t5 when v(vclk)=0.6 rise=29
let period4 =(t5 - t4)
let freq4 =1/period4

meas tran t6 when v(vclk)=0.6 rise=30
let period5 =(t6 - t5)
let freq5 =1/period5

meas tran t7 when v(vclk)=0.6 rise=31
let period6 =(t7 - t6)
let freq6 =1/period6

meas tran t8 when v(vclk)=0.6 rise=32
let period7 =(t8 - t7)
let freq7 =1/period7

meas tran t9 when v(vclk)=0.6 rise=33
let period8 =(t9 - t8)
let freq8 =1/period8

meas tran t10 when v(vclk)=0.6 rise=34
let period9 =(t10 - t9)
let freq9 =1/period9

meas tran t11 when v(vclk)=0.6 rise=35
let period10 =(t11 - t10)
let freq10 =1/period10

meas tran t12 when v(vclk)=0.6 rise=36
let period11 =(t12 - t11)
let freq11 =1/period11

meas tran t13 when v(vclk)=0.6 rise=37
let period12 =(t13 - t12)
let freq12 =1/period12

meas tran t14 when v(vclk)=0.6 rise=38
let period13 =(t14 - t13)
let freq13 =1/period13

meas tran t15 when v(vclk)=0.6 rise=39
let period14 =(t15 - t14)
let freq14 =1/period14

meas tran t16 when v(vclk)=0.6 rise=40
let period15 =(t16 - t15)
let freq15 =1/period15

meas tran t17 when v(vclk)=0.6 rise=41
let period16 =(t17 - t16)
let freq16 =1/period16

meas tran t18 when v(vclk)=0.6 rise=42
let period17 =(t18 - t17)
let freq17 =1/period17

meas tran t19 when v(vclk)=0.6 rise=43
let period18 =(t19 - t18)
let freq18 =1/period18

meas tran t20 when v(vclk)=0.6 rise=44
let period19 =(t20 - t19)
let freq19 =1/period19

meas tran t21 when v(vclk)=0.6 rise=54
let period20 =(t21 - t20)/10
let freq20 =1/period20

let duty_cycle =thigh/(period1)*100

print freq1
print freq2
print freq3
print freq4
print freq5
print freq6
print freq7
print freq8
print freq9
print freq10
print freq11
print freq12
print freq13
print freq14
print freq15
print freq16
print freq17
print freq18
print freq19
print freq20

print thigh
print tlow
print RiseTime
print FallTime
print duty_cycle
print total_power

 write clock_extractor_10mars2026.raw
.endc
K1 L9 L11  0.7

**** end user architecture code
**.ends
.GLOBAL GND
.GLOBAL VDD
.GLOBAL VDD1
.GLOBAL VDD2
.end
