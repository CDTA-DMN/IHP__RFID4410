* NGSPICE file created from Clock_Extractor_2026.ext - technology: ihp-sg13g2

.subckt Clock_Extractor_2026 VDD VSS vdd_1v2 vin_N vin_P v_bm vclk
X0 VDD.t30 VDD.t28 VDD.t29 VDD.t18 sg13_hv_pmos ad=1.53p pd=9.68u as=0 ps=0 w=4.5u l=1u
X1 VSS.t27 VSS.t25 VSS.t26 VSS.t2 sg13_hv_nmos ad=0.408p pd=3.08u as=0 ps=0 w=1.2u l=0.45u
X2 2stage_ota_0.drain_M2_M12_outputOTA.t3 2stage_ota_0.gate_M2.t3 VDD.t12 VDD.t1 sg13_hv_pmos ad=0.38p pd=2.38u as=0.38p ps=2.38u w=2u l=1.5u
X3 VDD.t12 2stage_ota_0.gate_M2.t3 2stage_ota_0.drain_M2_M12_outputOTA.t4 VDD.t1 sg13_hv_pmos ad=0.38p pd=2.38u as=0.38p ps=2.38u w=2u l=1.5u
X4 current_mirror3_0.drain_M1.t5 vin_P.t0 current_mirror_loadN_0.drain_M10.t3 VDD.t1 sg13_hv_pmos ad=1.53p pd=9.68u as=1.53p ps=9.68u w=4.5u l=1u
X5 VSS.t11 current_mirror_loadN_0.drain_M10.t4 2stage_ota_0.drain_M2_M12_outputOTA.t1 VSS.t10 sg13_hv_nmos ad=0.228p pd=1.58u as=0.228p ps=1.58u w=1.2u l=0.8u
X6 vdd_1v2.t1 2stage_ota_0.drain_M2_M12_outputOTA.t6 inverter_hv_0.vout_hv.t0 vdd_1v2.t0 sg13_hv_pmos ad=0.4862p pd=3.54u as=0.4862p ps=3.54u w=1.43u l=0.4u
X7 VDD.t13 2stage_ota_0.gate_M2.t3 2stage_ota_0.drain_M2_M12_outputOTA.t5 VDD.t1 sg13_hv_pmos ad=0.38p pd=2.38u as=0.38p ps=2.38u w=2u l=1.5u
X8 2stage_ota_0.drain_M2_M12_outputOTA.t5 2stage_ota_0.gate_M2.t3 VDD.t16 VDD.t1 sg13_hv_pmos ad=0.38p pd=2.38u as=0.38p ps=2.38u w=2u l=1.5u
X9 VSS.t13 current_mirror_loadN_0.drain_M10.t4 2stage_ota_0.drain_M2_M12_outputOTA.t2 VSS.t10 sg13_hv_nmos ad=0.228p pd=1.58u as=0.408p ps=3.08u w=1.2u l=0.8u
X10 vclk.t0 inverter_hv_0.vout_hv.t3 VSS.t1 VSS.t0 sg13_lv_nmos ad=0.2516p pd=2.16u as=0.2516p ps=2.16u w=0.74u l=0.13u
X11 VDD.t24 VDD.t22 VDD.t23 VDD.t18 sg13_hv_pmos ad=1.53p pd=9.68u as=0 ps=0 w=4.5u l=1u
X12 2stage_ota_0.gate_M2.t0 VDD.t17 VDD.t19 VDD.t18 sg13_hv_pmos ad=0.38p pd=2.38u as=0.68p ps=4.68u w=2u l=1.5u
X13 current_mirror3_0.drain_M1.t3 2stage_ota_0.gate_M2.t2 VDD.t7 VDD.t9 sg13_hv_pmos ad=0.38p pd=2.38u as=0.38p ps=2.38u w=2u l=1.5u
X14 VDD.t11 VDD.t34 VDD.t35 VDD.t1 sg13_hv_pmos ad=0.68p pd=4.68u as=0 ps=0 w=2u l=1.5u
X15 VDD.t6 2stage_ota_0.gate_M2.t2 2stage_ota_0.gate_M2.t0 VDD.t8 sg13_hv_pmos ad=0.38p pd=2.38u as=0.38p ps=2.38u w=2u l=1.5u
X16 VDD.t33 VDD.t25 VDD.t32 VDD.t10 sg13_hv_pmos ad=1.53p pd=9.68u as=0 ps=0 w=4.5u l=1u
X17 VSS.t24 VSS.t19 VSS.t23 VSS.t4 sg13_hv_nmos ad=0.408p pd=3.08u as=0 ps=0 w=1.2u l=0.45u
X18 2stage_ota_0.drain_M2_M12_outputOTA.t0 current_mirror_loadN_0.drain_M10.t4 VSS.t11 VSS.t10 sg13_hv_nmos ad=0.408p pd=3.08u as=0.228p ps=1.58u w=1.2u l=0.8u
X19 VDD.t4 VDD.t20 VDD.t4 VDD.t2 sg13_hv_pmos ad=0.38p pd=2.38u as=0 ps=0 w=2u l=1.5u
X20 VSS.t3 current_mirror_loadN_0.drain_M11.t2 current_mirror_loadN_0.drain_M10.t0 VSS.t2 sg13_hv_nmos ad=0.408p pd=3.08u as=0.408p ps=3.08u w=1.2u l=0.8u
X21 current_mirror_loadN_0.drain_M10.t2 vin_P.t0 current_mirror3_0.drain_M1.t6 VDD.t0 sg13_hv_pmos ad=1.53p pd=9.68u as=1.53p ps=9.68u w=4.5u l=1u
X22 VSS.t35 v_bm.t0 v_bm.t1 VSS.t32 sg13_hv_nmos ad=0.57p pd=3.38u as=0.57p ps=3.38u w=3u l=10u
X23 2stage_ota_0.drain_M2_M12_outputOTA.t1 current_mirror_loadN_0.drain_M10.t4 VSS.t13 VSS.t10 sg13_hv_nmos ad=0.228p pd=1.58u as=0.228p ps=1.58u w=1.2u l=0.8u
X24 VSS.t18 VSS.t15 VSS.t17 VSS.t16 sg13_hv_nmos ad=1.02p pd=6.68u as=0 ps=0 w=3u l=10u
X25 VDD.t27 VDD.t25 VDD.t26 VDD.t10 sg13_hv_pmos ad=1.53p pd=9.68u as=0 ps=0 w=4.5u l=1u
X26 current_mirror_loadN_0.drain_M11.t4 current_mirror_loadN_0.drain_M11.t2 VSS.t7 VSS.t2 sg13_hv_nmos ad=0.408p pd=3.08u as=0.408p ps=3.08u w=1.2u l=0.8u
X27 2stage_ota_0.gate_M2.t1 v_bm.t0 VSS.t35 VSS.t32 sg13_hv_nmos ad=0.57p pd=3.38u as=0.57p ps=3.38u w=3u l=10u
X28 current_mirror_loadN_0.drain_M11.t1 vin_N.t1 current_mirror3_0.drain_M1.t0 VDD.t0 sg13_hv_pmos ad=1.53p pd=9.68u as=1.53p ps=9.68u w=4.5u l=1u
X29 VDD.t11 2stage_ota_0.gate_M2.t3 2stage_ota_0.drain_M2_M12_outputOTA.t3 VDD.t1 sg13_hv_pmos ad=0.38p pd=2.38u as=0.38p ps=2.38u w=2u l=1.5u
X30 VSS.t5 current_mirror_loadN_0.drain_M11.t2 current_mirror_loadN_0.drain_M11.t3 VSS.t4 sg13_hv_nmos ad=0.408p pd=3.08u as=0.408p ps=3.08u w=1.2u l=0.8u
X31 VDD.t3 2stage_ota_0.gate_M2.t2 current_mirror3_0.drain_M1.t3 VDD.t10 sg13_hv_pmos ad=0.38p pd=2.38u as=0.38p ps=2.38u w=2u l=1.5u
X32 current_mirror3_0.drain_M1.t4 2stage_ota_0.gate_M2.t2 VDD.t3 VDD.t2 sg13_hv_pmos ad=0.38p pd=2.38u as=0.38p ps=2.38u w=2u l=1.5u
X33 VSS.t18 v_bm.t0 2stage_ota_0.gate_M2.t1 VSS.t34 sg13_hv_nmos ad=0.57p pd=3.38u as=0.57p ps=3.38u w=3u l=10u
X34 current_mirror_loadN_0.drain_M10.t1 current_mirror_loadN_0.drain_M11.t2 VSS.t6 VSS.t4 sg13_hv_nmos ad=0.408p pd=3.08u as=0.408p ps=3.08u w=1.2u l=0.8u
X35 inverter_hv_0.vout_hv.t1 2stage_ota_0.drain_M2_M12_outputOTA.t7 VSS.t9 VSS.t8 sg13_hv_nmos ad=0.357p pd=2.78u as=0.357p ps=2.78u w=1.05u l=0.45u
X36 VSS.t30 VSS.t25 VSS.t29 VSS.t4 sg13_hv_nmos ad=0.408p pd=3.08u as=0 ps=0 w=1.2u l=0.45u
X37 2stage_ota_0.drain_M2_M12_outputOTA.t4 2stage_ota_0.gate_M2.t3 VDD.t13 VDD.t1 sg13_hv_pmos ad=0.38p pd=2.38u as=0.38p ps=2.38u w=2u l=1.5u
X38 current_mirror3_0.drain_M1.t2 2stage_ota_0.gate_M2.t2 VDD.t6 VDD.t5 sg13_hv_pmos ad=0.38p pd=2.38u as=0.38p ps=2.38u w=2u l=1.5u
X39 VDD.t38 VDD.t36 VDD.t16 VDD.t1 sg13_hv_pmos ad=0.38p pd=2.38u as=0 ps=0 w=2u l=1.5u
X40 v_bm.t1 VSS.t31 VSS.t33 VSS.t32 sg13_hv_nmos ad=0.57p pd=3.38u as=1.02p ps=6.68u w=3u l=10u
X41 VDD.t7 2stage_ota_0.gate_M2.t2 current_mirror3_0.drain_M1.t2 VDD.t1 sg13_hv_pmos ad=0.38p pd=2.38u as=0.38p ps=2.38u w=2u l=1.5u
X42 VDD.t4 2stage_ota_0.gate_M2.t2 current_mirror3_0.drain_M1.t4 VDD.t2 sg13_hv_pmos ad=0.38p pd=2.38u as=0.38p ps=2.38u w=2u l=1.5u
X43 VSS.t21 VSS.t19 VSS.t20 VSS.t2 sg13_hv_nmos ad=0.408p pd=3.08u as=0 ps=0 w=1.2u l=0.45u
X44 current_mirror3_0.drain_M1.t1 vin_N.t0 current_mirror_loadN_0.drain_M11.t0 VDD.t1 sg13_hv_pmos ad=1.53p pd=9.68u as=1.53p ps=9.68u w=4.5u l=1u
X45 vdd_1v2.t2 inverter_hv_0.vout_hv.t2 vclk.t1 vdd_1v2.t0 sg13_lv_pmos ad=0.3808p pd=2.92u as=0.3808p ps=2.92u w=1.12u l=0.13u
C0 vin_P 2stage_ota_0.gate_M2 0.08557f
C1 vin_P vin_N 2.14632f
C2 vin_P VDD 1.85443f
C3 v_bm 2stage_ota_0.gate_M2 0.24841f
C4 current_mirror_loadN_0.drain_M11 2stage_ota_0.gate_M2 0.06874f
C5 v_bm vin_N 0.12793f
C6 current_mirror_loadN_0.drain_M11 vin_N 0.254f
C7 v_bm VDD 0.07878f
C8 VDD vdd_1v2 0.08149f
C9 current_mirror_loadN_0.drain_M11 VDD 0.77408f
C10 vin_N 2stage_ota_0.gate_M2 0.066f
C11 VDD 2stage_ota_0.gate_M2 10.7829f
C12 VDD vin_N 1.65234f
C13 current_mirror3_0.drain_M1 current_mirror_loadN_0.drain_M10 0.3464f
C14 vclk inverter_hv_0.vout_hv 0.74167f
C15 current_mirror_loadN_0.drain_M10 vclk 0.03852f
C16 vin_P current_mirror_loadN_0.drain_M10 0.20285f
C17 vdd_1v2 inverter_hv_0.vout_hv 0.85217f
C18 v_bm current_mirror_loadN_0.drain_M10 0.02087f
C19 2stage_ota_0.drain_M2_M12_outputOTA vclk 0.08878f
C20 current_mirror_loadN_0.drain_M11 current_mirror_loadN_0.drain_M10 1.36863f
C21 2stage_ota_0.drain_M2_M12_outputOTA vdd_1v2 0.48725f
C22 current_mirror_loadN_0.drain_M10 2stage_ota_0.gate_M2 0.35156f
C23 current_mirror_loadN_0.drain_M10 vin_N 0.17842f
C24 VDD current_mirror_loadN_0.drain_M10 1.25937f
C25 2stage_ota_0.drain_M2_M12_outputOTA 2stage_ota_0.gate_M2 0.52654f
C26 2stage_ota_0.drain_M2_M12_outputOTA VDD 1.32391f
C27 current_mirror3_0.drain_M1 vin_P 0.24962f
C28 current_mirror3_0.drain_M1 current_mirror_loadN_0.drain_M11 0.33902f
C29 vdd_1v2 vclk 0.6723f
C30 v_bm vin_P 0.16819f
C31 current_mirror_loadN_0.drain_M11 vin_P 0.05998f
C32 current_mirror3_0.drain_M1 2stage_ota_0.gate_M2 0.52971f
C33 vclk 2stage_ota_0.gate_M2 0.19814f
C34 current_mirror3_0.drain_M1 vin_N 0.2638f
C35 current_mirror3_0.drain_M1 VDD 2.5984f
C36 VDD vclk 0.48719f
C37 2stage_ota_0.drain_M2_M12_outputOTA inverter_hv_0.vout_hv 0.28015f
C38 2stage_ota_0.drain_M2_M12_outputOTA current_mirror_loadN_0.drain_M10 0.62354f
R0 vclk.n0 vclk.t0 21.1276
R1 vclk.n0 vclk.t1 15.0503
R2 vclk vclk.n0 13.8187
R3 vin_P vin_P.t0 20.1146
R4 vin_N.n0 vin_N.t0 13.616
R5 vin_N.n0 vin_N.t1 12.045
R6 vin_N vin_N.n0 8.0635
R7 v_bm.n0 v_bm.t0 15.0005
R8 v_bm v_bm.n0 10.2902
R9 v_bm.n0 v_bm.t1 3.12718
R10 vdd_1v2.n48 vdd_1v2.n0 17.0005
R11 vdd_1v2.n49 vdd_1v2.n48 17.0005
R12 vdd_1v2.t0 vdd_1v2.n12 8.501
R13 vdd_1v2.t0 vdd_1v2.n11 8.501
R14 vdd_1v2.t0 vdd_1v2.n10 8.501
R15 vdd_1v2.t0 vdd_1v2.n9 8.501
R16 vdd_1v2.t0 vdd_1v2.n6 8.501
R17 vdd_1v2.t0 vdd_1v2.n5 8.501
R18 vdd_1v2.t0 vdd_1v2.n4 8.501
R19 vdd_1v2.t0 vdd_1v2.n2 8.501
R20 vdd_1v2.n47 vdd_1v2.t0 8.501
R21 vdd_1v2.t0 vdd_1v2.n14 8.501
R22 vdd_1v2.t0 vdd_1v2.n46 8.501
R23 vdd_1v2.n34 vdd_1v2.n16 8.46995
R24 vdd_1v2.n33 vdd_1v2.n17 8.46995
R25 vdd_1v2.n32 vdd_1v2.n18 8.46995
R26 vdd_1v2.n31 vdd_1v2.n19 8.46995
R27 vdd_1v2.n38 vdd_1v2.n37 8.46995
R28 vdd_1v2.n42 vdd_1v2.n41 8.46995
R29 vdd_1v2.n3 vdd_1v2.n1 8.46995
R30 vdd_1v2.n43 vdd_1v2.n15 8.46995
R31 vdd_1v2.n45 vdd_1v2.n44 8.46995
R32 vdd_1v2.n40 vdd_1v2.n39 8.46358
R33 vdd_1v2.n50 vdd_1v2.t2 6.21147
R34 vdd_1v2.t0 vdd_1v2.n8 5.66767
R35 vdd_1v2.n36 vdd_1v2.n35 5.62486
R36 vdd_1v2.n23 vdd_1v2.t1 4.90439
R37 vdd_1v2.n27 vdd_1v2.n26 4.18441
R38 vdd_1v2.n24 vdd_1v2.n7 3.3033
R39 vdd_1v2.n29 vdd_1v2.n19 1.71154
R40 vdd_1v2.n21 vdd_1v2.n7 1.69723
R41 vdd_1v2.t0 vdd_1v2.n13 1.30908
R42 vdd_1v2.n22 vdd_1v2.n20 1.29981
R43 vdd_1v2.n23 vdd_1v2.n22 1.17442
R44 vdd_1v2.n29 vdd_1v2.n28 0.613561
R45 vdd_1v2.n21 vdd_1v2.n20 0.584631
R46 vdd_1v2.n25 vdd_1v2.n21 0.506308
R47 vdd_1v2.n30 vdd_1v2.n29 0.487309
R48 vdd_1v2.n24 vdd_1v2.n23 0.42147
R49 vdd_1v2.t0 vdd_1v2.n7 0.371065
R50 vdd_1v2.n25 vdd_1v2.n24 0.31698
R51 vdd_1v2.n27 vdd_1v2.n0 0.297627
R52 vdd_1v2.n38 vdd_1v2.n36 0.294297
R53 vdd_1v2 vdd_1v2.n50 0.285206
R54 vdd_1v2.n36 vdd_1v2.n34 0.276441
R55 vdd_1v2.n33 vdd_1v2.n32 0.265045
R56 vdd_1v2.n42 vdd_1v2.n40 0.263108
R57 vdd_1v2.n40 vdd_1v2.n38 0.263108
R58 vdd_1v2.n28 vdd_1v2.n25 0.257167
R59 vdd_1v2.n30 vdd_1v2.n20 0.257167
R60 vdd_1v2.n32 vdd_1v2.n31 0.250378
R61 vdd_1v2.n34 vdd_1v2.n33 0.250378
R62 vdd_1v2.n43 vdd_1v2.n1 0.250378
R63 vdd_1v2.n44 vdd_1v2.n42 0.250378
R64 vdd_1v2.n44 vdd_1v2.n43 0.195378
R65 vdd_1v2.n49 vdd_1v2.n1 0.187772
R66 vdd_1v2.n22 vdd_1v2.n7 0.187023
R67 vdd_1v2.n28 vdd_1v2.n27 0.146561
R68 vdd_1v2.n31 vdd_1v2.n30 0.132772
R69 vdd_1v2.n50 vdd_1v2.n0 0.0903333
R70 vdd_1v2.n50 vdd_1v2.n49 0.05
R71 vdd_1v2.n19 vdd_1v2.n13 0.00153847
R72 vdd_1v2.n26 vdd_1v2.n13 0.00146151
R73 vdd_1v2.n26 vdd_1v2.n2 0.001
R74 vdd_1v2.n48 vdd_1v2.n47 0.001
R75 vdd_1v2.n14 vdd_1v2.n3 0.001
R76 vdd_1v2.n46 vdd_1v2.n15 0.001
R77 vdd_1v2.n45 vdd_1v2.n4 0.001
R78 vdd_1v2.n41 vdd_1v2.n5 0.001
R79 vdd_1v2.n39 vdd_1v2.n6 0.001
R80 vdd_1v2.n37 vdd_1v2.n8 0.001
R81 vdd_1v2.n19 vdd_1v2.n9 0.001
R82 vdd_1v2.n18 vdd_1v2.n10 0.001
R83 vdd_1v2.n17 vdd_1v2.n11 0.001
R84 vdd_1v2.n16 vdd_1v2.n12 0.001
R85 vdd_1v2.n35 vdd_1v2.n12 0.001
R86 vdd_1v2.n16 vdd_1v2.n11 0.001
R87 vdd_1v2.n17 vdd_1v2.n10 0.001
R88 vdd_1v2.n18 vdd_1v2.n9 0.001
R89 vdd_1v2.n35 vdd_1v2.n8 0.001
R90 vdd_1v2.n37 vdd_1v2.n6 0.001
R91 vdd_1v2.n39 vdd_1v2.n5 0.001
R92 vdd_1v2.n41 vdd_1v2.n4 0.001
R93 vdd_1v2.n46 vdd_1v2.n45 0.001
R94 vdd_1v2.n48 vdd_1v2.n2 0.001
R95 vdd_1v2.n47 vdd_1v2.n3 0.001
R96 vdd_1v2.n15 vdd_1v2.n14 0.001
R97 VDD.n28 VDD.t20 15.4646
R98 VDD.n66 VDD.t17 15.4646
R99 VDD.n52 VDD.t28 15.0005
R100 VDD.n33 VDD.t25 15.0005
R101 VDD.n37 VDD.t34 15.0005
R102 VDD.n41 VDD.t36 15.0005
R103 VDD.n1 VDD.t22 15.0005
R104 VDD.t4 VDD.n27 6.31046
R105 VDD.n25 VDD.t6 6.31046
R106 VDD.n37 VDD.t11 4.37939
R107 VDD.n41 VDD.t16 4.37939
R108 VDD.n7 VDD.n2 4.251
R109 VDD.n9 VDD.n2 4.251
R110 VDD.n11 VDD.n2 4.251
R111 VDD.n12 VDD.n2 4.251
R112 VDD.n14 VDD.n2 4.251
R113 VDD.n15 VDD.n2 4.251
R114 VDD.n18 VDD.n2 4.251
R115 VDD.n22 VDD.n2 4.251
R116 VDD.n69 VDD.n23 4.2505
R117 VDD.n69 VDD.n21 4.2505
R118 VDD.n69 VDD.t0 4.2505
R119 VDD.n69 VDD.n13 4.2505
R120 VDD.n69 VDD.t8 4.2505
R121 VDD.n69 VDD.n10 4.2505
R122 VDD.n69 VDD.n8 4.2505
R123 VDD.n45 VDD.t13 4.18845
R124 VDD.n47 VDD.t12 4.18845
R125 VDD.n69 VDD.n4 4.17429
R126 VDD.n49 VDD.n36 4.17416
R127 VDD.n27 VDD.t3 3.87752
R128 VDD.n25 VDD.t7 3.87752
R129 VDD.n38 VDD.t35 3.60595
R130 VDD.n42 VDD.t38 3.60595
R131 VDD.n28 VDD.t4 3.54938
R132 VDD.n66 VDD.t19 3.54938
R133 VDD.n1 VDD.t24 3.35677
R134 VDD.n1 VDD.t23 3.35677
R135 VDD.n52 VDD.t30 3.35228
R136 VDD.n52 VDD.t29 3.35228
R137 VDD.n34 VDD.t32 3.22958
R138 VDD.n32 VDD.t33 3.22958
R139 VDD.n34 VDD.t26 3.18041
R140 VDD.n32 VDD.t27 3.18041
R141 VDD.n16 VDD.n2 2.83444
R142 VDD.n69 VDD.t9 2.83383
R143 VDD.n73 VDD.n2 2.29256
R144 VDD.n20 VDD.n2 2.126
R145 VDD.n69 VDD.t10 2.1255
R146 VDD.n69 VDD.t5 2.1255
R147 VDD.n49 VDD.n46 1.49173
R148 VDD.n53 VDD.n3 1.4767
R149 VDD.n29 VDD.n19 1.42997
R150 VDD.n70 VDD.n5 1.42722
R151 VDD.n69 VDD.t1 1.41717
R152 VDD.n19 VDD.n5 1.40753
R153 VDD.n44 VDD.n43 1.39062
R154 VDD.n43 VDD.n40 1.38197
R155 VDD.n40 VDD.n39 1.36688
R156 VDD.n45 VDD.n44 1.35185
R157 VDD.n59 VDD.n34 1.35144
R158 VDD.n72 VDD.n3 1.33042
R159 VDD.n58 VDD.n57 1.32342
R160 VDD.n71 VDD.n70 1.3218
R161 VDD.n59 VDD.n58 1.29155
R162 VDD.n17 VDD.n2 1.21526
R163 VDD.n54 VDD.n2 1.19748
R164 VDD.n26 VDD.n25 1.19109
R165 VDD.n62 VDD.n60 1.14501
R166 VDD.n60 VDD.n59 1.13889
R167 VDD.n64 VDD.n63 1.08915
R168 VDD.n2 VDD.n0 1.07427
R169 VDD.n69 VDD.n30 1.07408
R170 VDD.n48 VDD.n35 1.06061
R171 VDD.n61 VDD.n31 1.05208
R172 VDD.n27 VDD.n26 1.04874
R173 VDD.n48 VDD.n47 1.03004
R174 VDD.n65 VDD.n31 1.00521
R175 VDD.n63 VDD.n62 0.986865
R176 VDD.n56 VDD.n2 0.963169
R177 VDD.n68 VDD.n65 0.930448
R178 VDD.n56 VDD.n55 0.893112
R179 VDD.n50 VDD.n49 0.863285
R180 VDD.n68 VDD.n67 0.841481
R181 VDD.n64 VDD.n0 0.799656
R182 VDD.n51 VDD.n50 0.793635
R183 VDD.n69 VDD.n68 0.792497
R184 VDD.n50 VDD.n35 0.789031
R185 VDD.n61 VDD.n30 0.746632
R186 VDD.n57 VDD.n56 0.740169
R187 VDD.n30 VDD.n29 0.708143
R188 VDD VDD.n0 0.697308
R189 VDD.n55 VDD.n54 0.671111
R190 VDD.n54 VDD.n53 0.664288
R191 VDD.n46 VDD.n45 0.649853
R192 VDD VDD.n46 0.649382
R193 VDD.n39 VDD.n38 0.584875
R194 VDD.n43 VDD.n42 0.584875
R195 VDD.n69 VDD.n6 0.550414
R196 VDD.n29 VDD.n28 0.529875
R197 VDD.n67 VDD.n66 0.529875
R198 VDD.n49 VDD.n48 0.497547
R199 VDD.n63 VDD.n2 0.497028
R200 VDD.n69 VDD.n31 0.493201
R201 VDD.n73 VDD.n72 0.489845
R202 VDD.n34 VDD.n33 0.48175
R203 VDD.n33 VDD.n32 0.468
R204 VDD.n74 VDD.n73 0.458374
R205 VDD.n74 VDD.n1 0.427808
R206 VDD.n38 VDD.n37 0.409563
R207 VDD.n42 VDD.n41 0.409563
R208 VDD.n53 VDD.n52 0.400308
R209 VDD.n60 VDD.n2 0.381044
R210 VDD.n69 VDD.t2 0.321255
R211 VDD.n71 VDD.n4 0.311262
R212 VDD.n24 VDD.n2 0.304541
R213 VDD.n5 VDD 0.290167
R214 VDD.n67 VDD.n4 0.282191
R215 VDD.n39 VDD.n36 0.282062
R216 VDD.n6 VDD.n2 0.270445
R217 VDD.n55 VDD.n51 0.257167
R218 VDD.n57 VDD.n35 0.257167
R219 VDD.n72 VDD.n71 0.257167
R220 VDD.n65 VDD.n64 0.257167
R221 VDD.n62 VDD.n61 0.257167
R222 VDD.n51 VDD.n36 0.256395
R223 VDD.n58 VDD.n2 0.192408
R224 VDD.n26 VDD.n5 0.136167
R225 VDD.n49 VDD.t1 0.127366
R226 VDD.n49 VDD.n44 0.0966127
R227 VDD.n49 VDD.n40 0.068206
R228 VDD.n69 VDD.n19 0.065276
R229 VDD.n70 VDD.n69 0.0532863
R230 VDD.n3 VDD.n2 0.0257035
R231 VDD VDD.n74 0.0151667
R232 VDD.t18 VDD.n6 0.00524529
R233 VDD.n47 VDD 0.00233333
R234 VDD.n24 VDD.n23 0.00196424
R235 VDD.t9 VDD.n17 0.00178571
R236 VDD.n21 VDD.n20 0.00175
R237 VDD.t1 VDD.n16 0.00166667
R238 VDD.n16 VDD.t5 0.00133331
R239 VDD.n20 VDD.t10 0.00124997
R240 VDD.n17 VDD.t1 0.00121424
R241 VDD.t2 VDD.n24 0.00103571
R242 VDD.n22 VDD.n21 0.001
R243 VDD.n18 VDD.t9 0.001
R244 VDD.n15 VDD.t0 0.001
R245 VDD.n14 VDD.n13 0.001
R246 VDD.n12 VDD.t8 0.001
R247 VDD.n11 VDD.n10 0.001
R248 VDD.n9 VDD.n8 0.001
R249 VDD.n7 VDD.t18 0.001
R250 VDD.n8 VDD.n7 0.001
R251 VDD.n10 VDD.n9 0.001
R252 VDD.t8 VDD.n11 0.001
R253 VDD.n13 VDD.n12 0.001
R254 VDD.t0 VDD.n14 0.001
R255 VDD.t5 VDD.n15 0.001
R256 VDD.t10 VDD.n18 0.001
R257 VDD.n23 VDD.n22 0.001
R258 VSS.n106 VSS.n105 57.6668
R259 VSS.t32 VSS.n104 50.2471
R260 VSS.t34 VSS.n81 44.1001
R261 VSS.n82 VSS.t34 39.2002
R262 VSS.n33 VSS.n21 25.4389
R263 VSS.n105 VSS.t32 24.9077
R264 VSS.n34 VSS.n33 24.1464
R265 VSS.n35 VSS.n34 24.1464
R266 VSS.n36 VSS.n35 24.1464
R267 VSS.n37 VSS.n36 24.1464
R268 VSS.n38 VSS.n37 24.1464
R269 VSS.n39 VSS.n38 24.1464
R270 VSS.n40 VSS.n39 24.1464
R271 VSS.n41 VSS.n40 24.1464
R272 VSS.n42 VSS.n41 24.1464
R273 VSS.n43 VSS.n42 24.1464
R274 VSS.n44 VSS.n43 24.1464
R275 VSS.n45 VSS.n44 24.1464
R276 VSS.n46 VSS.n45 24.1464
R277 VSS.n47 VSS.n46 24.1464
R278 VSS.n48 VSS.n47 24.1464
R279 VSS.n49 VSS.n48 24.1464
R280 VSS.n50 VSS.n49 24.1464
R281 VSS.n52 VSS.n51 24.1464
R282 VSS.n53 VSS.n52 24.1464
R283 VSS.n54 VSS.n53 24.1464
R284 VSS.n55 VSS.n54 24.1464
R285 VSS.n56 VSS.n55 24.1464
R286 VSS.n57 VSS.n56 24.1464
R287 VSS.n58 VSS.n57 24.1464
R288 VSS.n59 VSS.n58 24.1464
R289 VSS.n60 VSS.n59 24.1464
R290 VSS.n61 VSS.n60 24.1464
R291 VSS.n62 VSS.n61 24.1464
R292 VSS.n63 VSS.n62 24.1464
R293 VSS.n64 VSS.n63 24.1464
R294 VSS.n65 VSS.n64 24.1464
R295 VSS.n66 VSS.n65 24.1464
R296 VSS.n67 VSS.n66 24.1464
R297 VSS.n68 VSS.n67 24.1464
R298 VSS.n69 VSS.n68 24.1464
R299 VSS.n70 VSS.n69 24.1464
R300 VSS.n71 VSS.n70 24.1464
R301 VSS.n72 VSS.n71 24.1464
R302 VSS.n73 VSS.n72 24.1464
R303 VSS.n74 VSS.n73 24.1464
R304 VSS.n75 VSS.n74 24.1464
R305 VSS.n76 VSS.n75 24.1464
R306 VSS.n77 VSS.n76 24.1464
R307 VSS.n78 VSS.n77 24.1464
R308 VSS.n79 VSS.n78 24.1464
R309 VSS.n80 VSS.n79 24.1464
R310 VSS.n84 VSS.n83 24.1464
R311 VSS.n85 VSS.n84 24.1464
R312 VSS.n86 VSS.n85 24.1464
R313 VSS.n87 VSS.n86 24.1464
R314 VSS.n88 VSS.n87 24.1464
R315 VSS.n89 VSS.n88 24.1464
R316 VSS.n90 VSS.n89 24.1464
R317 VSS.n91 VSS.n90 24.1464
R318 VSS.n92 VSS.n91 24.1464
R319 VSS.n93 VSS.n92 24.1464
R320 VSS.n94 VSS.n93 24.1464
R321 VSS.n95 VSS.n94 24.1464
R322 VSS.n96 VSS.n95 24.1464
R323 VSS.n97 VSS.n96 24.1464
R324 VSS.n98 VSS.n97 24.1464
R325 VSS.n99 VSS.n98 24.1464
R326 VSS.n100 VSS.n99 24.1464
R327 VSS.n101 VSS.n100 24.1464
R328 VSS.t0 VSS.n32 20.1606
R329 VSS.n134 VSS.t4 18.4449
R330 VSS.n133 VSS.n117 17.1581
R331 VSS.n82 VSS.n16 17.0005
R332 VSS.n81 VSS.n16 17.0005
R333 VSS.n18 VSS.t15 15.0005
R334 VSS.n14 VSS.t31 15.0005
R335 VSS.n119 VSS.t25 15.0005
R336 VSS.n28 VSS.t19 15.0005
R337 VSS.n104 VSS.n103 14.7683
R338 VSS.n17 VSS.n15 14.1115
R339 VSS.n170 VSS.n115 12.8687
R340 VSS.n154 VSS.n116 12.8687
R341 VSS.t16 VSS.n50 12.0734
R342 VSS.n81 VSS.n80 12.0734
R343 VSS.n103 VSS.n101 12.0734
R344 VSS.n83 VSS.n82 12.0734
R345 VSS.n51 VSS.t16 12.0734
R346 VSS.t10 VSS.n165 12.0108
R347 VSS.n144 VSS.n123 11.1529
R348 VSS.n131 VSS.n124 11.1529
R349 VSS.n165 VSS.n125 11.1529
R350 VSS.n127 VSS.n126 11.1529
R351 VSS.n103 VSS.n102 10.2001
R352 VSS.n171 VSS.n170 9.43716
R353 VSS.n154 VSS.n133 9.43716
R354 VSS.n167 VSS.n145 9.43716
R355 VSS.n153 VSS.n132 9.43716
R356 VSS.t2 VSS.t8 9.43716
R357 VSS.n127 VSS.t0 9.00822
R358 VSS.n236 VSS.t1 8.86193
R359 VSS.n202 VSS.n32 8.50125
R360 VSS.n144 VSS.n140 8.501
R361 VSS.n144 VSS.n141 8.501
R362 VSS.n144 VSS.n142 8.501
R363 VSS.n170 VSS.n146 8.501
R364 VSS.n170 VSS.n147 8.501
R365 VSS.n170 VSS.n148 8.501
R366 VSS.n170 VSS.n149 8.501
R367 VSS.n198 VSS.n173 8.501
R368 VSS.n198 VSS.n174 8.501
R369 VSS.n198 VSS.n175 8.501
R370 VSS.n198 VSS.n176 8.501
R371 VSS.n198 VSS.n177 8.501
R372 VSS.n198 VSS.n178 8.501
R373 VSS.n198 VSS.n179 8.501
R374 VSS.n198 VSS.n197 8.501
R375 VSS.n199 VSS.n198 8.501
R376 VSS.n217 VSS.n22 8.501
R377 VSS.n217 VSS.n23 8.501
R378 VSS.n217 VSS.n24 8.501
R379 VSS.n217 VSS.n25 8.501
R380 VSS.n217 VSS.n216 8.501
R381 VSS.n217 VSS.n20 8.501
R382 VSS.n218 VSS.n217 8.501
R383 VSS.n126 VSS.n10 8.5005
R384 VSS.n131 VSS.n10 8.5005
R385 VSS.n32 VSS.n10 8.5005
R386 VSS.n165 VSS.n10 8.5005
R387 VSS.n168 VSS.n127 8.5005
R388 VSS.n168 VSS.n153 8.5005
R389 VSS.n168 VSS.n154 8.5005
R390 VSS.n168 VSS.n166 8.5005
R391 VSS.n168 VSS.n167 8.5005
R392 VSS.n200 VSS.n31 8.5005
R393 VSS.n200 VSS.n127 8.5005
R394 VSS.n200 VSS.n132 8.5005
R395 VSS.n200 VSS.n133 8.5005
R396 VSS.n200 VSS.n134 8.5005
R397 VSS.n201 VSS.n200 8.5005
R398 VSS.n200 VSS.n32 8.5005
R399 VSS.n200 VSS.n125 8.5005
R400 VSS.n200 VSS.n145 8.5005
R401 VSS.n200 VSS.n171 8.5005
R402 VSS.n202 VSS.n201 8.5005
R403 VSS.n202 VSS.n127 8.5005
R404 VSS.n202 VSS.n125 8.5005
R405 VSS.n202 VSS.n124 8.5005
R406 VSS.n202 VSS.n123 8.5005
R407 VSS.n202 VSS.n117 8.5005
R408 VSS.n202 VSS.n116 8.5005
R409 VSS.n202 VSS.n115 8.5005
R410 VSS.n202 VSS.n31 8.5005
R411 VSS.n242 VSS.n11 8.46995
R412 VSS.n241 VSS.n12 8.46995
R413 VSS.n240 VSS.n13 8.46995
R414 VSS.n161 VSS.n150 8.46995
R415 VSS.n160 VSS.n155 8.46995
R416 VSS.n159 VSS.n156 8.46995
R417 VSS.n158 VSS.n157 8.46995
R418 VSS.n181 VSS.n180 8.46995
R419 VSS.n183 VSS.n182 8.46995
R420 VSS.n185 VSS.n184 8.46995
R421 VSS.n187 VSS.n186 8.46995
R422 VSS.n191 VSS.n190 8.46995
R423 VSS.n193 VSS.n192 8.46995
R424 VSS.n196 VSS.n195 8.46995
R425 VSS.n194 VSS.n172 8.46995
R426 VSS.n208 VSS.n207 8.46995
R427 VSS.n210 VSS.n209 8.46995
R428 VSS.n214 VSS.n213 8.46995
R429 VSS.n215 VSS.n19 8.46995
R430 VSS.n220 VSS.n219 8.46995
R431 VSS.n189 VSS.n188 8.45904
R432 VSS.n212 VSS.n211 8.44274
R433 VSS.n126 VSS.t2 7.29246
R434 VSS.n107 VSS.t5 7.06387
R435 VSS.n110 VSS.t6 7.06387
R436 VSS.n134 VSS.n115 6.86353
R437 VSS.n171 VSS.n116 6.86353
R438 VSS.n4 VSS.t13 6.77948
R439 VSS.n138 VSS.t11 6.77948
R440 VSS.n118 VSS.t29 6.3601
R441 VSS.n120 VSS.t30 6.3601
R442 VSS.n201 VSS.n129 6.34435
R443 VSS.n27 VSS.t21 6.30467
R444 VSS.n29 VSS.t20 6.30467
R445 VSS.n27 VSS.t24 6.29135
R446 VSS.n29 VSS.t23 6.29135
R447 VSS.n118 VSS.t26 6.23592
R448 VSS.n120 VSS.t27 6.23592
R449 VSS.n6 VSS.t9 6.16101
R450 VSS.n145 VSS.n144 6.00565
R451 VSS.n132 VSS.n131 6.00565
R452 VSS.n144 VSS.n143 5.66767
R453 VSS.n256 VSS.n2 5.63778
R454 VSS.n232 VSS.n2 5.61281
R455 VSS.n202 VSS.n114 5.56969
R456 VSS.n107 VSS.t3 5.53294
R457 VSS.n110 VSS.t7 5.53294
R458 VSS.n152 VSS.n31 5.37112
R459 VSS.n128 VSS.n31 5.37112
R460 VSS.n201 VSS.n128 5.37112
R461 VSS.n152 VSS.n32 5.37112
R462 VSS.t4 VSS.n114 5.17094
R463 VSS.n198 VSS.n114 4.49724
R464 VSS.n217 VSS.n21 4.45569
R465 VSS.n170 VSS.n169 4.25119
R466 VSS.n198 VSS.n135 4.25119
R467 VSS.n10 VSS.n9 4.18423
R468 VSS.n8 VSS.n2 4.17416
R469 VSS.n166 VSS.t10 3.43201
R470 VSS.n18 VSS.t17 3.39273
R471 VSS.n14 VSS.t33 3.39273
R472 VSS.n221 VSS.n16 3.31185
R473 VSS.n237 VSS.n10 3.31178
R474 VSS.n250 VSS.n2 3.3033
R475 VSS.n246 VSS.n2 3.3033
R476 VSS.n234 VSS.n2 3.3033
R477 VSS.n168 VSS.n163 2.72414
R478 VSS.n168 VSS.n164 2.72379
R479 VSS.n248 VSS.n2 2.71665
R480 VSS.n200 VSS.n139 2.70629
R481 VSS.n167 VSS.n117 2.57413
R482 VSS.n153 VSS.n123 2.57413
R483 VSS.n166 VSS.n124 2.57413
R484 VSS.n226 VSS.n225 2.525
R485 VSS.n34 VSS.n2 2.46478
R486 VSS.n36 VSS.n2 2.46478
R487 VSS.n38 VSS.n2 2.46478
R488 VSS.n40 VSS.n2 2.46478
R489 VSS.n42 VSS.n2 2.46478
R490 VSS.n44 VSS.n2 2.46478
R491 VSS.n46 VSS.n2 2.46478
R492 VSS.n48 VSS.n2 2.46478
R493 VSS.n50 VSS.n2 2.46478
R494 VSS.n52 VSS.n2 2.46478
R495 VSS.n54 VSS.n2 2.46478
R496 VSS.n56 VSS.n2 2.46478
R497 VSS.n58 VSS.n2 2.46478
R498 VSS.n60 VSS.n2 2.46478
R499 VSS.n62 VSS.n2 2.46478
R500 VSS.n64 VSS.n2 2.46478
R501 VSS.n66 VSS.n2 2.46478
R502 VSS.n68 VSS.n2 2.46478
R503 VSS.n70 VSS.n2 2.46478
R504 VSS.n72 VSS.n2 2.46478
R505 VSS.n74 VSS.n2 2.46478
R506 VSS.n76 VSS.n2 2.46478
R507 VSS.n78 VSS.n2 2.46478
R508 VSS.n80 VSS.n2 2.46478
R509 VSS.n83 VSS.n2 2.46478
R510 VSS.n85 VSS.n2 2.46478
R511 VSS.n87 VSS.n2 2.46478
R512 VSS.n89 VSS.n2 2.46478
R513 VSS.n91 VSS.n2 2.46478
R514 VSS.n93 VSS.n2 2.46478
R515 VSS.n95 VSS.n2 2.46478
R516 VSS.n97 VSS.n2 2.46478
R517 VSS.n99 VSS.n2 2.46478
R518 VSS.n101 VSS.n2 2.46478
R519 VSS.n100 VSS.n16 2.46478
R520 VSS.n98 VSS.n16 2.46478
R521 VSS.n96 VSS.n16 2.46478
R522 VSS.n94 VSS.n16 2.46478
R523 VSS.n92 VSS.n16 2.46478
R524 VSS.n90 VSS.n16 2.46478
R525 VSS.n88 VSS.n16 2.46478
R526 VSS.n86 VSS.n16 2.46478
R527 VSS.n84 VSS.n16 2.46478
R528 VSS.n79 VSS.n16 2.46478
R529 VSS.n77 VSS.n16 2.46478
R530 VSS.n75 VSS.n16 2.46478
R531 VSS.n73 VSS.n16 2.46478
R532 VSS.n71 VSS.n16 2.46478
R533 VSS.n69 VSS.n16 2.46478
R534 VSS.n67 VSS.n16 2.46478
R535 VSS.n65 VSS.n16 2.46478
R536 VSS.n63 VSS.n16 2.46478
R537 VSS.n61 VSS.n16 2.46478
R538 VSS.n59 VSS.n16 2.46478
R539 VSS.n57 VSS.n16 2.46478
R540 VSS.n55 VSS.n16 2.46478
R541 VSS.n53 VSS.n16 2.46478
R542 VSS.n51 VSS.n16 2.46478
R543 VSS.n49 VSS.n16 2.46478
R544 VSS.n47 VSS.n16 2.46478
R545 VSS.n45 VSS.n16 2.46478
R546 VSS.n43 VSS.n16 2.46478
R547 VSS.n41 VSS.n16 2.46478
R548 VSS.n39 VSS.n16 2.46478
R549 VSS.n37 VSS.n16 2.46478
R550 VSS.n35 VSS.n16 2.46478
R551 VSS.n33 VSS.n16 2.46478
R552 VSS.n203 VSS.n202 2.29273
R553 VSS.n202 VSS.n112 2.29267
R554 VSS.n239 VSS.n10 2.28269
R555 VSS.n200 VSS.n137 1.9761
R556 VSS.n202 VSS.n26 1.97603
R557 VSS.n202 VSS.n122 1.97054
R558 VSS.n243 VSS.n10 1.96625
R559 VSS.n106 VSS.n10 1.88939
R560 VSS.n17 VSS.t18 1.8148
R561 VSS.n15 VSS.t35 1.8148
R562 VSS.n224 VSS.n17 1.79413
R563 VSS.n227 VSS.n15 1.79413
R564 VSS.n202 VSS.n109 1.69826
R565 VSS.n208 VSS.n206 1.59216
R566 VSS.n128 VSS.n10 1.56594
R567 VSS.n168 VSS.n152 1.56594
R568 VSS.n168 VSS.n151 1.49372
R569 VSS.n168 VSS.n162 1.49312
R570 VSS.n228 VSS.n227 1.48083
R571 VSS.n206 VSS.n205 1.46164
R572 VSS.n229 VSS.n228 1.43768
R573 VSS.n231 VSS 1.4085
R574 VSS.n121 VSS.n113 1.40256
R575 VSS.n113 VSS.n30 1.36793
R576 VSS.n225 VSS.n224 1.3501
R577 VSS.t8 VSS.n125 1.28732
R578 VSS.n224 VSS.n223 1.24156
R579 VSS.n223 VSS.n222 1.22301
R580 VSS.n200 VSS.n136 1.187
R581 VSS.n227 VSS.n226 1.15089
R582 VSS.n194 VSS.n130 1.11118
R583 VSS.n257 VSS.n1 1.11056
R584 VSS.n230 VSS.n229 1.08085
R585 VSS.n254 VSS.n2 1.07427
R586 VSS.n205 VSS.n1 1.06193
R587 VSS.n129 VSS.n106 1.05822
R588 VSS.n252 VSS.n251 1.01056
R589 VSS.n231 VSS.n230 1.00948
R590 VSS.n253 VSS.n252 0.991305
R591 VSS.n130 VSS.n4 0.976363
R592 VSS.n108 VSS.n107 0.975475
R593 VSS.n111 VSS.n110 0.975475
R594 VSS.n21 VSS.n2 0.910548
R595 VSS.n104 VSS.n2 0.877955
R596 VSS.n255 VSS.n254 0.803322
R597 VSS.n181 VSS.n136 0.794148
R598 VSS.n136 VSS.n3 0.787334
R599 VSS.n200 VSS.n106 0.773227
R600 VSS.n254 VSS 0.766975
R601 VSS.n151 VSS.n7 0.709283
R602 VSS.n162 VSS.n5 0.70835
R603 VSS.n162 VSS.n161 0.707416
R604 VSS.n158 VSS.n151 0.706716
R605 VSS.n202 VSS.n106 0.6805
R606 VSS.n243 VSS.n242 0.578283
R607 VSS.n244 VSS.n243 0.567506
R608 VSS.n111 VSS.n109 0.562027
R609 VSS.n109 VSS.n108 0.555393
R610 VSS.n200 VSS.n130 0.545212
R611 VSS.n252 VSS.n2 0.544718
R612 VSS.n239 VSS.n238 0.515808
R613 VSS.n240 VSS.n239 0.514762
R614 VSS.n122 VSS.n121 0.504098
R615 VSS.n108 VSS.n26 0.503784
R616 VSS.n30 VSS.n29 0.4955
R617 VSS.n230 VSS.n2 0.491227
R618 VSS.n204 VSS.n203 0.489876
R619 VSS.n203 VSS.n30 0.483994
R620 VSS.n121 VSS.n120 0.468
R621 VSS.n138 VSS.n137 0.440922
R622 VSS.n112 VSS.n111 0.438126
R623 VSS.n112 VSS.n0 0.434933
R624 VSS.n139 VSS.n138 0.426322
R625 VSS.n139 VSS.n4 0.426322
R626 VSS.n122 VSS.n0 0.422015
R627 VSS.n221 VSS.n220 0.391377
R628 VSS.n248 VSS.n247 0.376655
R629 VSS.n137 VSS.n3 0.375929
R630 VSS.n204 VSS.n26 0.375368
R631 VSS.n164 VSS.n6 0.371481
R632 VSS.n163 VSS.n6 0.36731
R633 VSS.n250 VSS 0.362814
R634 VSS.n2 VSS.n1 0.351001
R635 VSS.n246 VSS.n245 0.346314
R636 VSS.n222 VSS.n18 0.340813
R637 VSS.n229 VSS.n14 0.340813
R638 VSS.n222 VSS.n221 0.328634
R639 VSS.n251 VSS.n250 0.320637
R640 VSS.n226 VSS.n2 0.31866
R641 VSS.n236 VSS.n9 0.312676
R642 VSS.n249 VSS.n248 0.310296
R643 VSS.n168 VSS.n129 0.309093
R644 VSS.n213 VSS.n212 0.304801
R645 VSS.n212 VSS.n210 0.304801
R646 VSS.n247 VSS.n246 0.302304
R647 VSS.n235 VSS.n8 0.300395
R648 VSS.n242 VSS.n241 0.279711
R649 VSS.n189 VSS.n187 0.272189
R650 VSS.n191 VSS.n189 0.272189
R651 VSS.n160 VSS.n159 0.268711
R652 VSS.n163 VSS.n5 0.262801
R653 VSS.n164 VSS.n7 0.262264
R654 VSS.n253 VSS.n4 0.254875
R655 VSS VSS.n234 0.254637
R656 VSS.n237 VSS.n236 0.251415
R657 VSS.n234 VSS.n233 0.25098
R658 VSS.n183 VSS.n181 0.250378
R659 VSS.n185 VSS.n183 0.250378
R660 VSS.n187 VSS.n185 0.250378
R661 VSS.n193 VSS.n191 0.250378
R662 VSS.n195 VSS.n193 0.250378
R663 VSS.n195 VSS.n194 0.250378
R664 VSS.n161 VSS.n160 0.250378
R665 VSS.n159 VSS.n158 0.250378
R666 VSS.n241 VSS.n240 0.250378
R667 VSS.n210 VSS.n208 0.250378
R668 VSS.n213 VSS.n19 0.250378
R669 VSS.n220 VSS.n19 0.250378
R670 VSS.n233 VSS.n232 0.246425
R671 VSS.n255 VSS.n3 0.246167
R672 VSS.n205 VSS.n204 0.246167
R673 VSS VSS.n257 0.2425
R674 VSS.n28 VSS.n27 0.23425
R675 VSS.n119 VSS.n118 0.230812
R676 VSS.n120 VSS.n119 0.230812
R677 VSS.n223 VSS.n16 0.229076
R678 VSS.n29 VSS.n28 0.227375
R679 VSS.n245 VSS.n8 0.212395
R680 VSS.n238 VSS.n237 0.204311
R681 VSS.n232 VSS.n231 0.194752
R682 VSS.n251 VSS.n5 0.191167
R683 VSS.n247 VSS.n7 0.191167
R684 VSS.n238 VSS.n233 0.191167
R685 VSS.n245 VSS.n244 0.191167
R686 VSS.n249 VSS.n6 0.151241
R687 VSS.n225 VSS.n16 0.150851
R688 VSS.n244 VSS.n9 0.146176
R689 VSS.n236 VSS.n235 0.145857
R690 VSS.n257 VSS.n256 0.0868035
R691 VSS.n202 VSS.n113 0.0742338
R692 VSS.n256 VSS.n255 0.0512112
R693 VSS.n228 VSS.n2 0.0204864
R694 VSS.n206 VSS.n2 0.0111583
R695 VSS VSS.n249 0.006
R696 VSS.n235 VSS 0.00416667
R697 VSS VSS.n0 0.00416667
R698 VSS VSS.n253 0.00233333
R699 VSS.n180 VSS.n135 0.00162501
R700 VSS.n169 VSS.n150 0.00162501
R701 VSS.n169 VSS.n168 0.00137498
R702 VSS.n200 VSS.n135 0.00137498
R703 VSS.n105 VSS.n2 0.0010138
R704 VSS.n102 VSS.n16 0.001
R705 VSS.n22 VSS.n2 0.001
R706 VSS.n207 VSS.n23 0.001
R707 VSS.n209 VSS.n24 0.001
R708 VSS.n211 VSS.n25 0.001
R709 VSS.n216 VSS.n214 0.001
R710 VSS.n215 VSS.n20 0.001
R711 VSS.n219 VSS.n218 0.001
R712 VSS.n180 VSS.n173 0.001
R713 VSS.n182 VSS.n174 0.001
R714 VSS.n184 VSS.n175 0.001
R715 VSS.n186 VSS.n176 0.001
R716 VSS.n188 VSS.n177 0.001
R717 VSS.n190 VSS.n178 0.001
R718 VSS.n192 VSS.n179 0.001
R719 VSS.n197 VSS.n196 0.001
R720 VSS.n199 VSS.n172 0.001
R721 VSS.n150 VSS.n146 0.001
R722 VSS.n155 VSS.n147 0.001
R723 VSS.n156 VSS.n148 0.001
R724 VSS.n157 VSS.n149 0.001
R725 VSS.n143 VSS.n11 0.001
R726 VSS.n140 VSS.n11 0.001
R727 VSS.n141 VSS.n12 0.001
R728 VSS.n142 VSS.n13 0.001
R729 VSS.n102 VSS.n2 0.001
R730 VSS.n143 VSS.n10 0.001
R731 VSS.n140 VSS.n12 0.001
R732 VSS.n141 VSS.n13 0.001
R733 VSS.n142 VSS.n10 0.001
R734 VSS.n155 VSS.n146 0.001
R735 VSS.n156 VSS.n147 0.001
R736 VSS.n157 VSS.n148 0.001
R737 VSS.n168 VSS.n149 0.001
R738 VSS.n182 VSS.n173 0.001
R739 VSS.n184 VSS.n174 0.001
R740 VSS.n186 VSS.n175 0.001
R741 VSS.n188 VSS.n176 0.001
R742 VSS.n190 VSS.n177 0.001
R743 VSS.n192 VSS.n178 0.001
R744 VSS.n196 VSS.n179 0.001
R745 VSS.n197 VSS.n172 0.001
R746 VSS.n200 VSS.n199 0.001
R747 VSS.n207 VSS.n22 0.001
R748 VSS.n209 VSS.n23 0.001
R749 VSS.n211 VSS.n24 0.001
R750 VSS.n214 VSS.n25 0.001
R751 VSS.n216 VSS.n215 0.001
R752 VSS.n219 VSS.n20 0.001
R753 VSS.n218 VSS.n16 0.001
R754 inverter_hv_0.vout_hv.t1 inverter_hv_0.vout_hv.n1 16.3766
R755 inverter_hv_0.vout_hv inverter_hv_0.vout_hv.n0 1.22177
R756 inverter_hv_0.vout_hv inverter_hv_0.vout_hv.n1 0.30528
R757 inverter_hv_0.vout_hv.n0 inverter_hv_0.vout_hv.t2 13.145
R758 inverter_hv_0.vout_hv.n0 inverter_hv_0.vout_hv.t3 14.8745
R759 inverter_hv_0.vout_hv.t0 inverter_hv_0.vout_hv.n1 14.0573
R760 2stage_ota_0.drain_M2_M12_outputOTA.t2 2stage_ota_0.drain_M2_M12_outputOTA.n5 7.66836
R761 2stage_ota_0.drain_M2_M12_outputOTA.n5 2stage_ota_0.drain_M2_M12_outputOTA.n0 0.1105
R762 2stage_ota_0.drain_M2_M12_outputOTA.n0 2stage_ota_0.drain_M2_M12_outputOTA.t0 7.77936
R763 2stage_ota_0.drain_M2_M12_outputOTA.n4 2stage_ota_0.drain_M2_M12_outputOTA.n5 10.0982
R764 2stage_ota_0.drain_M2_M12_outputOTA 2stage_ota_0.drain_M2_M12_outputOTA.n4 2.44397
R765 2stage_ota_0.drain_M2_M12_outputOTA.n3 2stage_ota_0.drain_M2_M12_outputOTA.n4 0.364233
R766 2stage_ota_0.drain_M2_M12_outputOTA 2stage_ota_0.drain_M2_M12_outputOTA.n3 0.00783333
R767 2stage_ota_0.drain_M2_M12_outputOTA.n3 2stage_ota_0.drain_M2_M12_outputOTA.n2 9.50047
R768 2stage_ota_0.drain_M2_M12_outputOTA.n2 2stage_ota_0.drain_M2_M12_outputOTA.n1 1.70894
R769 2stage_ota_0.drain_M2_M12_outputOTA.n1 2stage_ota_0.drain_M2_M12_outputOTA.t4 3.54408
R770 2stage_ota_0.drain_M2_M12_outputOTA.n1 2stage_ota_0.drain_M2_M12_outputOTA.t3 6.0186
R771 2stage_ota_0.drain_M2_M12_outputOTA.n2 2stage_ota_0.drain_M2_M12_outputOTA.t5 4.18002
R772 2stage_ota_0.drain_M2_M12_outputOTA.t7 2stage_ota_0.drain_M2_M12_outputOTA 14.1834
R773 2stage_ota_0.drain_M2_M12_outputOTA.t6 2stage_ota_0.drain_M2_M12_outputOTA 13.4068
R774 2stage_ota_0.drain_M2_M12_outputOTA.n0 2stage_ota_0.drain_M2_M12_outputOTA.t1 6.15686
R775 current_mirror_loadN_0.drain_M10.t1 current_mirror_loadN_0.drain_M10.n4 14.9489
R776 current_mirror_loadN_0.drain_M10.n3 current_mirror_loadN_0.drain_M10.n4 0.5703
R777 current_mirror_loadN_0.drain_M10.n3 current_mirror_loadN_0.drain_M10.n1 2.0157
R778 current_mirror_loadN_0.drain_M10.n2 current_mirror_loadN_0.drain_M10.n3 3.3841
R779 current_mirror_loadN_0.drain_M10 current_mirror_loadN_0.drain_M10.n2 0.0159
R780 current_mirror_loadN_0.drain_M10.n2 current_mirror_loadN_0.drain_M10.t4 12.6224
R781 current_mirror_loadN_0.drain_M10 current_mirror_loadN_0.drain_M10.n1 0.00201724
R782 current_mirror_loadN_0.drain_M10.n1 current_mirror_loadN_0.drain_M10.n0 2.1914
R783 current_mirror_loadN_0.drain_M10.n0 current_mirror_loadN_0.drain_M10.t2 12.593
R784 current_mirror_loadN_0.drain_M10.n0 current_mirror_loadN_0.drain_M10.t3 16.4037
R785 current_mirror_loadN_0.drain_M10.n4 current_mirror_loadN_0.drain_M10.t0 15.5457
R786 current_mirror_loadN_0.drain_M11.n2 current_mirror_loadN_0.drain_M11.t3 5.53294
R787 current_mirror_loadN_0.drain_M11.t4 current_mirror_loadN_0.drain_M11.n2 7.50865
R788 current_mirror_loadN_0.drain_M11.t2 current_mirror_loadN_0.drain_M11.n2 15.7902
R789 current_mirror_loadN_0.drain_M11.n1 current_mirror_loadN_0.drain_M11.t2 13.3562
R790 current_mirror_loadN_0.drain_M11 current_mirror_loadN_0.drain_M11.n1 0.00353448
R791 current_mirror_loadN_0.drain_M11.n0 current_mirror_loadN_0.drain_M11.t0 0.90581
R792 current_mirror_loadN_0.drain_M11.n1 current_mirror_loadN_0.drain_M11.n0 12.6501
R793 current_mirror_loadN_0.drain_M11.n0 current_mirror_loadN_0.drain_M11.t1 6.43362
R794 current_mirror3_0.drain_M1.n4 current_mirror3_0.drain_M1.n0 1.56456
R795 current_mirror3_0.drain_M1.n0 current_mirror3_0.drain_M1.t4 6.09175
R796 current_mirror3_0.drain_M1 current_mirror3_0.drain_M1.n4 9.47096
R797 current_mirror3_0.drain_M1 current_mirror3_0.drain_M1.n3 9.44353
R798 current_mirror3_0.drain_M1.n2 current_mirror3_0.drain_M1.t5 0.90581
R799 current_mirror3_0.drain_M1.n2 current_mirror3_0.drain_M1.t1 5.61629
R800 current_mirror3_0.drain_M1.n3 current_mirror3_0.drain_M1.n2 2.27271
R801 current_mirror3_0.drain_M1.n1 current_mirror3_0.drain_M1.t0 0.90581
R802 current_mirror3_0.drain_M1.n1 current_mirror3_0.drain_M1.t6 5.61629
R803 current_mirror3_0.drain_M1.n3 current_mirror3_0.drain_M1.n1 4.08509
R804 current_mirror3_0.drain_M1.n4 current_mirror3_0.drain_M1.t2 4.53026
R805 current_mirror3_0.drain_M1.n0 current_mirror3_0.drain_M1.t3 3.50923
R806 2stage_ota_0.gate_M2.t1 2stage_ota_0.gate_M2.n0 12.8542
R807 2stage_ota_0.gate_M2.n0 2stage_ota_0.gate_M2.n2 9.0005
R808 2stage_ota_0.gate_M2 2stage_ota_0.gate_M2.n0 0.00960345
R809 2stage_ota_0.gate_M2.n2 2stage_ota_0.gate_M2.n3 12.0987
R810 2stage_ota_0.gate_M2.n3 2stage_ota_0.gate_M2 0.0401
R811 2stage_ota_0.gate_M2.n3 2stage_ota_0.gate_M2.t3 14.7036
R812 2stage_ota_0.gate_M2.n2 2stage_ota_0.gate_M2 11.5061
R813 2stage_ota_0.gate_M2.t2 2stage_ota_0.gate_M2.n1 15.0005
R814 2stage_ota_0.gate_M2 2stage_ota_0.gate_M2.n1 13.618
R815 2stage_ota_0.gate_M2.t0 2stage_ota_0.gate_M2.n1 3.60595
C39 vclk VSS 2.68956f
C40 vin_P VSS 1.48695f
C41 vin_N VSS 1.17953f
C42 v_bm VSS 15.69876f
C43 vdd_1v2 VSS 0.87209f
C44 VDD VSS 4.26995f
C45 inverter_hv_0.vout_hv VSS 1.29713f $ **FLOATING
C46 2stage_ota_0.drain_M2_M12_outputOTA VSS 2.96519f $ **FLOATING
C47 current_mirror_loadN_0.drain_M10 VSS 2.64474f $ **FLOATING
C48 current_mirror_loadN_0.drain_M11 VSS 2.15414f $ **FLOATING
C49 current_mirror3_0.drain_M1 VSS 0.71423f $ **FLOATING
C50 2stage_ota_0.gate_M2 VSS 2.18985f $ **FLOATING
C51 2stage_ota_0.gate_M2.t1 VSS 0.34591f $ **FLOATING
C52 2stage_ota_0.gate_M2.n0 VSS 0.18708f $ **FLOATING
C53 2stage_ota_0.gate_M2.t2 VSS 5.79961f $ **FLOATING
C54 2stage_ota_0.gate_M2.t0 VSS 0.1738f $ **FLOATING
C55 2stage_ota_0.gate_M2.n1 VSS 0.25219f $ **FLOATING
C56 2stage_ota_0.gate_M2.n2 VSS 1.01876f $ **FLOATING
C57 2stage_ota_0.gate_M2.t3 VSS 4.37149f $ **FLOATING
C58 2stage_ota_0.gate_M2.n3 VSS 0.34003f $ **FLOATING
C59 current_mirror3_0.drain_M1.t4 VSS 0.27899f $ **FLOATING
C60 current_mirror3_0.drain_M1.t3 VSS 0.21113f $ **FLOATING
C61 current_mirror3_0.drain_M1.n0 VSS 0.29542f $ **FLOATING
C62 current_mirror3_0.drain_M1.t2 VSS 0.23665f $ **FLOATING
C63 current_mirror3_0.drain_M1.n1 VSS 0.34981f $ **FLOATING
C64 current_mirror3_0.drain_M1.t0 VSS 0.39252f $ **FLOATING
C65 current_mirror3_0.drain_M1.t6 VSS 0.60017f $ **FLOATING
C66 current_mirror3_0.drain_M1.n2 VSS 0.26793f $ **FLOATING
C67 current_mirror3_0.drain_M1.t5 VSS 0.39252f $ **FLOATING
C68 current_mirror3_0.drain_M1.t1 VSS 0.60017f $ **FLOATING
C69 current_mirror3_0.drain_M1.n3 VSS 0.29009f $ **FLOATING
C70 current_mirror3_0.drain_M1.n4 VSS 0.18923f $ **FLOATING
C71 current_mirror_loadN_0.drain_M11.t4 VSS 0.09091f $ **FLOATING
C72 current_mirror_loadN_0.drain_M11.t2 VSS 1.13857f $ **FLOATING
C73 current_mirror_loadN_0.drain_M11.n0 VSS 0.2761f $ **FLOATING
C74 current_mirror_loadN_0.drain_M11.t0 VSS 0.27891f $ **FLOATING
C75 current_mirror_loadN_0.drain_M11.t1 VSS 0.45307f $ **FLOATING
C76 current_mirror_loadN_0.drain_M11.n1 VSS 0.42766f $ **FLOATING
C77 current_mirror_loadN_0.drain_M11.n2 VSS 0.12793f $ **FLOATING
C78 current_mirror_loadN_0.drain_M11.t3 VSS 0.07438f $ **FLOATING
C79 current_mirror_loadN_0.drain_M10.t1 VSS 0.1313f $ **FLOATING
C80 current_mirror_loadN_0.drain_M10.t0 VSS 0.13481f $ **FLOATING
C81 current_mirror_loadN_0.drain_M10.t3 VSS 0.61212f $ **FLOATING
C82 current_mirror_loadN_0.drain_M10.t2 VSS 0.50051f $ **FLOATING
C83 current_mirror_loadN_0.drain_M10.n0 VSS 0.81238f $ **FLOATING
C84 current_mirror_loadN_0.drain_M10.n1 VSS 0.32807f $ **FLOATING
C85 current_mirror_loadN_0.drain_M10.t4 VSS 1.195f $ **FLOATING
C86 current_mirror_loadN_0.drain_M10.n2 VSS 0.22654f $ **FLOATING
C87 current_mirror_loadN_0.drain_M10.n3 VSS 0.29558f $ **FLOATING
C88 current_mirror_loadN_0.drain_M10.n4 VSS 0.14411f $ **FLOATING
C89 2stage_ota_0.drain_M2_M12_outputOTA.t2 VSS 0.10836f $ **FLOATING
C90 2stage_ota_0.drain_M2_M12_outputOTA.t1 VSS 0.10112f $ **FLOATING
C91 2stage_ota_0.drain_M2_M12_outputOTA.n0 VSS 0.16428f $ **FLOATING
C92 2stage_ota_0.drain_M2_M12_outputOTA.t6 VSS 0.22113f $ **FLOATING
C93 2stage_ota_0.drain_M2_M12_outputOTA.t7 VSS 0.20277f $ **FLOATING
C94 2stage_ota_0.drain_M2_M12_outputOTA.t5 VSS 0.19005f $ **FLOATING
C95 2stage_ota_0.drain_M2_M12_outputOTA.t3 VSS 0.2312f $ **FLOATING
C96 2stage_ota_0.drain_M2_M12_outputOTA.n1 VSS 0.25211f $ **FLOATING
C97 2stage_ota_0.drain_M2_M12_outputOTA.t4 VSS 0.17696f $ **FLOATING
C98 2stage_ota_0.drain_M2_M12_outputOTA.n2 VSS 0.16288f $ **FLOATING
C99 2stage_ota_0.drain_M2_M12_outputOTA.n3 VSS 0.09748f $ **FLOATING
C100 2stage_ota_0.drain_M2_M12_outputOTA.n4 VSS 0.50289f $ **FLOATING
C101 2stage_ota_0.drain_M2_M12_outputOTA.n5 VSS 0.14888f $ **FLOATING
C102 2stage_ota_0.drain_M2_M12_outputOTA.t0 VSS 0.10994f $ **FLOATING
C103 inverter_hv_0.vout_hv.t1 VSS 0.17506f $ **FLOATING
C104 inverter_hv_0.vout_hv.t0 VSS 0.21848f $ **FLOATING
C105 inverter_hv_0.vout_hv.t3 VSS 0.12918f $ **FLOATING
C106 inverter_hv_0.vout_hv.t2 VSS 0.13802f $ **FLOATING
C107 inverter_hv_0.vout_hv.n0 VSS 0.58096f $ **FLOATING
C108 inverter_hv_0.vout_hv.n1 VSS 0.53236f $ **FLOATING
C109 VDD.n0 VSS 0.01495f $ **FLOATING
C110 VDD.t23 VSS 0.06229f $ **FLOATING
C111 VDD.t24 VSS 0.06229f $ **FLOATING
C112 VDD.t22 VSS 0.14593f $ **FLOATING
C113 VDD.n1 VSS 0.03645f $ **FLOATING
C114 VDD.n2 VSS 0.58417f $ **FLOATING
C115 VDD.n3 VSS 0.10787f $ **FLOATING
C116 VDD.n5 VSS 0.07041f $ **FLOATING
C117 VDD.n6 VSS 1.15202f $ **FLOATING
C118 VDD.t18 VSS 1.30984f $ **FLOATING
C119 VDD.n8 VSS 0.49666f $ **FLOATING
C120 VDD.n10 VSS 0.49666f $ **FLOATING
C121 VDD.t8 VSS 0.49666f $ **FLOATING
C122 VDD.n13 VSS 0.41449f $ **FLOATING
C123 VDD.t0 VSS 0.5277f $ **FLOATING
C124 VDD.t5 VSS 1.01522f $ **FLOATING
C125 VDD.t1 VSS 5.02825f $ **FLOATING
C126 VDD.t9 VSS 0.7815f $ **FLOATING
C127 VDD.t10 VSS 0.99331f $ **FLOATING
C128 VDD.n19 VSS 0.07899f $ **FLOATING
C129 VDD.n21 VSS 0.49666f $ **FLOATING
C130 VDD.n23 VSS 0.49666f $ **FLOATING
C131 VDD.t2 VSS 2.01406f $ **FLOATING
C132 VDD.t3 VSS 0.02646f $ **FLOATING
C133 VDD.t7 VSS 0.02646f $ **FLOATING
C134 VDD.t6 VSS 0.03474f $ **FLOATING
C135 VDD.n25 VSS 0.03909f $ **FLOATING
C136 VDD.n26 VSS 0.01159f $ **FLOATING
C137 VDD.n27 VSS 0.03851f $ **FLOATING
C138 VDD.t4 VSS 0.05781f $ **FLOATING
C139 VDD.t20 VSS 0.09683f $ **FLOATING
C140 VDD.n28 VSS 0.01597f $ **FLOATING
C141 VDD.n29 VSS 0.04816f $ **FLOATING
C142 VDD.n30 VSS 0.01423f $ **FLOATING
C143 VDD.n31 VSS 0.02543f $ **FLOATING
C144 VDD.t26 VSS 0.06145f $ **FLOATING
C145 VDD.t32 VSS 0.06165f $ **FLOATING
C146 VDD.t27 VSS 0.06145f $ **FLOATING
C147 VDD.t33 VSS 0.06165f $ **FLOATING
C148 VDD.n32 VSS 0.03237f $ **FLOATING
C149 VDD.t25 VSS 0.30313f $ **FLOATING
C150 VDD.n34 VSS 0.03688f $ **FLOATING
C151 VDD.n35 VSS 0.03971f $ **FLOATING
C152 VDD.t11 VSS 0.02802f $ **FLOATING
C153 VDD.t34 VSS 0.09677f $ **FLOATING
C154 VDD.n37 VSS 0.0151f $ **FLOATING
C155 VDD.t35 VSS 0.02322f $ **FLOATING
C156 VDD.n38 VSS 0.01357f $ **FLOATING
C157 VDD.n39 VSS 0.03866f $ **FLOATING
C158 VDD.n40 VSS 0.07491f $ **FLOATING
C159 VDD.t16 VSS 0.02802f $ **FLOATING
C160 VDD.t36 VSS 0.09677f $ **FLOATING
C161 VDD.n41 VSS 0.0151f $ **FLOATING
C162 VDD.t38 VSS 0.02322f $ **FLOATING
C163 VDD.n42 VSS 0.01357f $ **FLOATING
C164 VDD.n43 VSS 0.06597f $ **FLOATING
C165 VDD.n44 VSS 0.0661f $ **FLOATING
C166 VDD.t13 VSS 0.02738f $ **FLOATING
C167 VDD.n45 VSS 0.05434f $ **FLOATING
C168 VDD.n46 VSS 0.01214f $ **FLOATING
C169 VDD.t12 VSS 0.02738f $ **FLOATING
C170 VDD.n47 VSS 0.03236f $ **FLOATING
C171 VDD.n48 VSS 0.0261f $ **FLOATING
C172 VDD.n49 VSS 0.43044f $ **FLOATING
C173 VDD.n50 VSS 0.01555f $ **FLOATING
C174 VDD.n51 VSS 0.02396f $ **FLOATING
C175 VDD.t29 VSS 0.0623f $ **FLOATING
C176 VDD.t30 VSS 0.0623f $ **FLOATING
C177 VDD.t28 VSS 0.14978f $ **FLOATING
C178 VDD.n52 VSS 0.03618f $ **FLOATING
C179 VDD.n53 VSS 0.05126f $ **FLOATING
C180 VDD.n54 VSS 0.01253f $ **FLOATING
C181 VDD.n55 VSS 0.03036f $ **FLOATING
C182 VDD.n56 VSS 0.0168f $ **FLOATING
C183 VDD.n57 VSS 0.04452f $ **FLOATING
C184 VDD.n58 VSS 0.04802f $ **FLOATING
C185 VDD.n59 VSS 0.05395f $ **FLOATING
C186 VDD.n60 VSS 0.03164f $ **FLOATING
C187 VDD.n61 VSS 0.03656f $ **FLOATING
C188 VDD.n62 VSS 0.04636f $ **FLOATING
C189 VDD.n63 VSS 0.02583f $ **FLOATING
C190 VDD.n64 VSS 0.03698f $ **FLOATING
C191 VDD.n65 VSS 0.03942f $ **FLOATING
C192 VDD.t19 VSS 0.02307f $ **FLOATING
C193 VDD.t17 VSS 0.09683f $ **FLOATING
C194 VDD.n66 VSS 0.01597f $ **FLOATING
C195 VDD.n67 VSS 0.02192f $ **FLOATING
C196 VDD.n68 VSS 0.01923f $ **FLOATING
C197 VDD.n69 VSS 0.46804f $ **FLOATING
C198 VDD.n70 VSS 0.0817f $ **FLOATING
C199 VDD.n71 VSS 0.0423f $ **FLOATING
C200 VDD.n72 VSS 0.04685f $ **FLOATING
C201 VDD.n74 VSS 0.01175f $ **FLOATING
C202 vdd_1v2.t2 VSS 0.01291f $ **FLOATING
C203 vdd_1v2.n7 VSS 0.16003f $ **FLOATING
C204 vdd_1v2.n19 VSS 0.0363f $ **FLOATING
C205 vdd_1v2.n20 VSS 0.0436f $ **FLOATING
C206 vdd_1v2.t1 VSS 0.01724f $ **FLOATING
C207 vdd_1v2.n22 VSS 0.04814f $ **FLOATING
C208 vdd_1v2.n23 VSS 0.05662f $ **FLOATING
C209 vdd_1v2.n25 VSS 0.02007f $ **FLOATING
C210 vdd_1v2.n26 VSS 0.01296f $ **FLOATING
C211 vdd_1v2.n28 VSS 0.0183f $ **FLOATING
C212 vdd_1v2.n29 VSS 0.0102f $ **FLOATING
C213 vdd_1v2.n30 VSS 0.01615f $ **FLOATING
C214 vdd_1v2.t0 VSS 1.43832f $ **FLOATING
C215 vdd_1v2.n50 VSS 0.0181f $ **FLOATING
C216 v_bm.t0 VSS 0.6375f $ **FLOATING
C217 vin_N.t0 VSS 1.57789f $ **FLOATING
C218 vin_N.t1 VSS 1.5949f $ **FLOATING
C219 vin_N.n0 VSS 0.92292f $ **FLOATING
C220 vin_P.t0 VSS 3.78068f $ **FLOATING
C221 vclk.t0 VSS 0.12468f $ **FLOATING
C222 vclk.t1 VSS 0.14112f $ **FLOATING
C223 vclk.n0 VSS 1.16833f $ **FLOATING
.ends
