.subckt Clock_Extractor_2026 VDD VSS
.ends
.end
