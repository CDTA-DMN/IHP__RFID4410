* NGSPICE file created from pmu_tagwave.ext - technology: ihp-sg13g2

.subckt pmu_tagwave VR VFB Vbg VDD VSS IOVDD
X0 VR.t10 beta_multiplier_0.beta_multiplier_startup_0.beta_multiplier_startup_enable_0.VS1.t4 ldo_brahim_0.I_Bias.t10 VSS.t64 sg13_hv_nmos ad=3.4p pd=20.68u as=3.4p ps=20.68u w=10u l=0.45u
X1 VSS.t160 VSS.t63 VSS.t159 VSS.t46 sg13_hv_nmos ad=3.4p pd=20.68u as=0 ps=0 w=10u l=0.45u
X2 a_6646_7350.t0 a_8732_8406.t0 VSS.t1 rhigh l=10u w=0.5u
X3 ldo_brahim_0.ldo_brahim_opamp_2_stage_0/ldo_brahim_tail_0.tail.t2 ldo_brahim_0.I_Bias.t16 IOVDD.t27 IOVDD.t3 sg13_hv_pmos ad=1.9p pd=10.38u as=1.9p ps=10.38u w=10u l=2u
X4 IOVDD.t178 IOVDD.t75 IOVDD.t177 IOVDD.t57 sg13_hv_pmos ad=0.17p pd=1.68u as=0 ps=0 w=0.5u l=3u
X5 VR.t9 beta_multiplier_0.beta_multiplier_startup_0.beta_multiplier_startup_enable_0.VS1.t4 ldo_brahim_0.I_Bias.t12 VSS.t64 sg13_hv_nmos ad=3.4p pd=20.68u as=3.4p ps=20.68u w=10u l=0.45u
X6 IOVDD.t175 IOVDD.t144 IOVDD.t174 IOVDD.t1 sg13_hv_pmos ad=1.7p pd=10.68u as=0 ps=0 w=5u l=1u
X7 IOVDD.t217 bgr_djalal_0.bgr_djalal_ota_1_stage_0.Vout1.t5 cap_cmim l=7u w=7u
X8 ldo_brahim_0.I_Bias.t13 beta_multiplier_0.beta_multiplier_startup_0.beta_multiplier_startup_enable_0.VS1.t5 VR.t8 VSS.t64 sg13_hv_nmos ad=3.4p pd=20.68u as=3.4p ps=20.68u w=10u l=0.45u
X9 a_8732_8142.t1 a_11060_8142.t0 VSS.t1 rhigh l=10u w=0.5u
X10 VDD.t1 ldo_brahim_0.ldo_brahim_pass_element2_0.VG2.t10 IOVDD.t210 VSS.t184 sg13_hv_nmos ad=1.9p pd=10.38u as=1.9p ps=10.38u w=10u l=0.45u
X11 IOVDD.t172 IOVDD.t97 IOVDD.t171 IOVDD.t3 sg13_hv_pmos ad=1.7p pd=10.68u as=0 ps=0 w=5u l=2u
X12 IOVDD.t218 bgr_djalal_0.bgr_djalal_ota_1_stage_0.Vout1.t10 cap_cmim l=7u w=7u
X13 IOVDD.t169 IOVDD.t36 IOVDD.t27 IOVDD.t3 sg13_hv_pmos ad=1.9p pd=10.38u as=0 ps=0 w=10u l=2u
X14 ldo_brahim_0.I_Bias.t5 beta_multiplier_0.beta_multiplier_startup_0.beta_multiplier_startup_enable_0.VS1.t5 VR.t7 VSS.t46 sg13_hv_nmos ad=3.4p pd=20.68u as=3.4p ps=20.68u w=10u l=0.45u
X15 a_5046_11016.t1 a_5310_7848.t0 VSS.t4 rhigh l=15.41u w=0.5u
X16 a_11060_7350.t0 a_13388_7350.t1 VSS.t1 rhigh l=10u w=0.5u
X17 VSS.t157 VSS.t43 VSS.t31 VSS.t56 sg13_hv_nmos ad=2.55p pd=15.68u as=0 ps=0 w=7.5u l=1u
X18 ldo_brahim_0.ldo_brahim_opamp_2_stage_0/ldo_brahim_cs_0.VG.t1 Vbg.t4 ldo_brahim_0.ldo_brahim_opamp_2_stage_0/ldo_brahim_tail_0.tail.t3 IOVDD.t3 sg13_hv_pmos ad=1.7p pd=10.68u as=1.7p ps=10.68u w=5u l=2u
X19 beta_multiplier_0.beta_multiplier_startup_0.beta_multiplier_startup_enable_0.VS1.t0 beta_multiplier_0.beta_multiplier_startup_0.beta_multiplier_startup_mirror_0.VS2.t3 IOVDD.t2 IOVDD.t1 sg13_hv_pmos ad=1.7p pd=10.68u as=1.7p ps=10.68u w=5u l=1u
X20 IOVDD.t166 IOVDD.t161 IOVDD.t165 IOVDD.t126 sg13_hv_pmos ad=0.68p pd=4.68u as=0 ps=0 w=2u l=1u
X21 IOVDD.t195 ldo_brahim_0.ldo_brahim_pass_element2_0.VG2.t10 VDD.t22 VSS.t185 sg13_hv_nmos ad=1.9p pd=10.38u as=1.9p ps=10.38u w=10u l=0.45u
X22 IOVDD.t163 IOVDD.t161 IOVDD.t162 IOVDD.t126 sg13_hv_pmos ad=0.68p pd=4.68u as=0 ps=0 w=2u l=1u
X23 a_13630_7878.t1 a_15716_7614.t1 VSS.t0 rhigh l=10u w=0.5u
X24 IOVDD.t188 bgr_djalal_0.bgr_djalal_ota_1_stage_0.Vout1.t11 Vbg.t3 IOVDD.t126 sg13_hv_pmos ad=0.17p pd=1.68u as=0.17p ps=1.68u w=0.5u l=3u
X25 a_13630_7878.t0 a_15716_8142.t1 VSS.t0 rhigh l=10u w=0.5u
X26 ldo_brahim_0.I_Bias.t15 beta_multiplier_0.beta_multiplier_mirror_0.VN.t3 VR.t11 VSS.t46 sg13_hv_nmos ad=1.9p pd=10.38u as=3.4p ps=20.68u w=10u l=1u
X27 ldo_brahim_0.ldo_brahim_opamp_2_stage_0/ldo_brahim_cs_0.VG.t4 a_5183_1757.t1 cap_cmim l=28u w=9u
X28 a_2835_2443.t0 a_4959_2576.t0 VSS.t9 rhigh l=9u w=0.5u
X29 ldo_brahim_0.ldo_brahim_pass_element2_0.VG2.t1 ldo_brahim_0.I_Bias.t17 IOVDD.t16 IOVDD.t3 sg13_hv_pmos ad=1.9p pd=10.38u as=1.9p ps=10.38u w=10u l=2u
X30 VSS.t33 VSS.t43 VSS.t33 VSS.t92 sg13_hv_nmos ad=2.7p pd=8.22u as=0 ps=0 w=7.5u l=1u
X31 IOVDD.t216 ldo_brahim_0.ldo_brahim_pass_element2_0.VG2.t10 VDD.t28 VSS.t185 sg13_hv_nmos ad=3.4p pd=20.68u as=1.9p ps=10.38u w=10u l=0.45u
X32 IOVDD.t160 IOVDD.t32 IOVDD.t159 IOVDD.t33 sg13_hv_pmos ad=3.4p pd=20.68u as=0 ps=0 w=10u l=5u
X33 VSS.t6 VSS.t7 VSS.t1 rhigh l=10u w=0.5u
X34 IOVDD.t204 ldo_brahim_0.ldo_brahim_pass_element2_0.VG2.t10 VDD.t27 VSS.t187 sg13_hv_nmos ad=1.9p pd=10.38u as=1.9p ps=10.38u w=10u l=0.45u
X35 VDD.t13 ldo_brahim_0.ldo_brahim_pass_element2_0.VG2.t10 IOVDD.t204 VSS.t187 sg13_hv_nmos ad=1.9p pd=10.38u as=1.9p ps=10.38u w=10u l=0.45u
X36 IOVDD.t157 IOVDD.t155 IOVDD.t14 IOVDD.t156 sg13_hv_pmos ad=3.4p pd=20.68u as=0 ps=0 w=10u l=2u
X37 VSS.t152 VSS.t49 VSS.t151 VSS.t17 sg13_hv_nmos ad=0.34p pd=2.68u as=0 ps=0 w=1u l=10u
X38 a_15958_7878.t0 a_18044_7614.t0 VSS.t8 rhigh l=10u w=0.5u
X39 ldo_brahim_0.ldo_brahim_pass_element2_0.VG2.t9 ldo_brahim_0.ldo_brahim_opamp_2_stage_0/ldo_brahim_cs_0.VG.t5 VSS.t125 VSS.t180 sg13_hv_nmos ad=1.9p pd=10.38u as=1.9p ps=10.38u w=10u l=2u
X40 ldo_brahim_0.ldo_brahim_opamp_2_stage_0/ldo_brahim_cs_0.VG.t6 a_5183_1757.t0 cap_cmim l=27u w=45u
X41 a_2835_2443.t1 ldo_brahim_0.ldo_brahim_pass_element2_0.VG2.t5 VSS.t25 rhigh l=3u w=0.5u
X42 bgr_djalal_0.bgr_djalal_ota_1_stage_0.bgr_djalal_ota_tail_0.tail.t6 bgr_djalal_0.bgr_djalal_ota_1_stage_0.VN.t4 bgr_djalal_0.bgr_djalal_ota_1_stage_0.Vout1.t0 IOVDD.t31 sg13_hv_pmos ad=3.4p pd=20.68u as=3.4p ps=20.68u w=10u l=5u
X43 VSS.t18 bgr_djalal_0.bgr_djalal_ota_1_stage_0.bgr_djalal_ota_mirror_0.Iref.t2 bgr_djalal_0.bgr_djalal_ota_1_stage_0.Vout1.t3 VSS.t17 sg13_hv_nmos ad=0.34p pd=2.68u as=0.34p ps=2.68u w=1u l=10u
X44 a_15958_7878.t1 bgr_djalal_0.bgr_djalal_ota_1_stage_0.VP.t3 VSS.t8 rhigh l=10u w=0.5u
X45 VSS.t149 VSS.t111 VSS.t148 VSS.t112 sg13_hv_nmos ad=3.4p pd=20.68u as=0 ps=0 w=10u l=2u
X46 VSS.t146 VSS.t127 VSS.t145 VSS.t128 sg13_hv_nmos ad=0.34p pd=2.68u as=0 ps=0 w=1u l=10u
X47 VSS.t116 VR.t15 beta_multiplier_0.beta_multiplier_mirror_0.VN.t2 VSS.t64 sg13_hv_nmos ad=1.9p pd=10.38u as=1.9p ps=10.38u w=10u l=1u
X48 IOVDD.t219 bgr_djalal_0.bgr_djalal_ota_1_stage_0.Vout1.t9 cap_cmim l=7u w=7u
X49 IOVDD.t154 IOVDD.t75 IOVDD.t153 IOVDD.t57 sg13_hv_pmos ad=0.17p pd=1.68u as=0 ps=0 w=0.5u l=3u
X50 VSS.t33 bgr_djalal_0.bgr_djalal_resistors_0.VP1.t3 bgr_djalal_0.bgr_djalal_resistors_0.VP1.t4 VSS.t32 sg13_hv_nmos ad=2.7p pd=8.22u as=2.55p ps=15.68u w=7.5u l=4u
X51 VDD.t28 ldo_brahim_0.ldo_brahim_pass_element2_0.VG2.t10 IOVDD.t213 VSS.t185 sg13_hv_nmos ad=1.9p pd=10.38u as=1.9p ps=10.38u w=10u l=0.45u
X52 VSS.t143 VSS.t59 VSS.t142 VSS.t60 sg13_hv_nmos ad=3.4p pd=20.68u as=0 ps=0 w=10u l=2u
X53 IOVDD.t151 IOVDD.t119 IOVDD.t150 IOVDD.t1 sg13_hv_pmos ad=1.7p pd=10.68u as=0 ps=0 w=5u l=1u
X54 ldo_brahim_0.ldo_brahim_pass_element2_0.VG2.t8 ldo_brahim_0.ldo_brahim_opamp_2_stage_0/ldo_brahim_cs_0.VG.t5 VSS.t122 VSS.t180 sg13_hv_nmos ad=1.9p pd=10.38u as=1.9p ps=10.38u w=10u l=2u
X55 ldo_brahim_0.ldo_brahim_opamp_2_stage_0/ldo_brahim_tail_0.tail.t4 Vbg.t5 ldo_brahim_0.ldo_brahim_opamp_2_stage_0/ldo_brahim_cs_0.VG.t0 IOVDD.t3 sg13_hv_pmos ad=1.7p pd=10.68u as=1.7p ps=10.68u w=5u l=2u
X56 a_5838_14426.t1 a_5574_11258.t1 VSS.t4 rhigh l=15.41u w=0.5u
X57 a_13630_7350.t0 a_15716_7614.t0 VSS.t0 rhigh l=10u w=0.5u
X58 beta_multiplier_0.beta_multiplier_startup_0.beta_multiplier_startup_mirror_0.VS2.t4 VSS.t21 cap_cmim l=6.63u w=10u
X59 IOVDD.t20 IOVDD.t87 IOVDD.t148 IOVDD.t3 sg13_hv_pmos ad=3.4p pd=20.68u as=0 ps=0 w=10u l=2u
X60 IOVDD.t146 IOVDD.t144 IOVDD.t145 IOVDD.t1 sg13_hv_pmos ad=1.7p pd=10.68u as=0 ps=0 w=5u l=1u
X61 ldo_brahim_0.ldo_brahim_opamp_2_stage_0/ldo_brahim_cs_0.VG.t3 ldo_brahim_0.ldo_brahim_opamp_2_stage_0/ldo_brahim_mirror_0.i_ref.t2 VSS.t40 VSS.t35 sg13_hv_nmos ad=3.4p pd=20.68u as=3.4p ps=20.68u w=10u l=2u
X62 ldo_brahim_0.ldo_brahim_opamp_2_stage_0/ldo_brahim_tail_0.tail.t1 ldo_brahim_0.I_Bias.t17 IOVDD.t10 IOVDD.t3 sg13_hv_pmos ad=1.9p pd=10.38u as=1.9p ps=10.38u w=10u l=2u
X63 IOVDD.t23 ldo_brahim_0.I_Bias.t18 bgr_djalal_0.bgr_djalal_ota_1_stage_0.bgr_djalal_ota_tail_0.tail.t1 IOVDD.t24 sg13_hv_pmos ad=1.9p pd=10.38u as=1.9p ps=10.38u w=10u l=2u
X64 VR.t6 beta_multiplier_0.beta_multiplier_startup_0.beta_multiplier_startup_enable_0.VS1.t5 ldo_brahim_0.I_Bias.t8 VSS.t46 sg13_hv_nmos ad=3.4p pd=20.68u as=3.4p ps=20.68u w=10u l=0.45u
X65 VSS.t167 VSS.t168 VSS.t1 rhigh l=10u w=0.5u
X66 VSS.t42 a_4959_2048.t0 VSS.t41 rhigh l=9u w=0.5u
X67 ldo_brahim_0.I_Bias.t6 beta_multiplier_0.beta_multiplier_startup_0.beta_multiplier_startup_enable_0.VS1.t4 VR.t5 VSS.t64 sg13_hv_nmos ad=3.4p pd=20.68u as=3.4p ps=20.68u w=10u l=0.45u
X68 a_5574_11016.t1 a_5838_7848.t1 VSS.t4 rhigh l=15.41u w=0.5u
X69 VSS.t140 VSS.t137 VSS.t139 VSS.t138 sg13_hv_nmos ad=1.36p pd=8.68u as=0 ps=0 w=4u l=2u
X70 IOVDD.t220 bgr_djalal_0.bgr_djalal_ota_1_stage_0.Vout1.t8 cap_cmim l=7u w=7u
X71 VDD.t8 ldo_brahim_0.ldo_brahim_pass_element2_0.VG2.t10 IOVDD.t211 VSS.t184 sg13_hv_nmos ad=1.9p pd=10.38u as=1.9p ps=10.38u w=10u l=0.45u
X72 IOVDD.t215 ldo_brahim_0.ldo_brahim_pass_element2_0.VG2.t10 VDD.t26 VSS.t185 sg13_hv_nmos ad=3.4p pd=20.68u as=1.9p ps=10.38u w=10u l=0.45u
X73 IOVDD.t211 ldo_brahim_0.ldo_brahim_pass_element2_0.VG2.t10 VDD.t24 VSS.t184 sg13_hv_nmos ad=1.9p pd=10.38u as=1.9p ps=10.38u w=10u l=0.45u
X74 IOVDD.t187 bgr_djalal_0.bgr_djalal_ota_1_stage_0.Vout1.t11 bgr_djalal_0.bgr_djalal_ota_1_stage_0.VP.t2 IOVDD.t126 sg13_hv_pmos ad=0.17p pd=1.68u as=0.17p ps=1.68u w=0.5u l=3u
X75 VSS.t110 VSS.t107 VSS.t109 VSS.t108 sg13_hv_nmos ad=1.36p pd=8.68u as=0 ps=0 w=4u l=2u
X76 a_15716_7350.t1 a_18044_7614.t1 VSS.t8 rhigh l=10u w=0.5u
X77 IOVDD.t143 IOVDD.t141 IOVDD.t142 IOVDD.t43 sg13_hv_pmos ad=0.68p pd=4.68u as=0 ps=0 w=2u l=1u
X78 VDD.t27 ldo_brahim_0.ldo_brahim_pass_element2_0.VG2.t10 IOVDD.t214 VSS.t187 sg13_hv_nmos ad=1.9p pd=10.38u as=1.9p ps=10.38u w=10u l=0.45u
X79 IOVDD.t140 IOVDD.t39 IOVDD.t139 IOVDD.t1 sg13_hv_pmos ad=1.7p pd=10.68u as=0 ps=0 w=5u l=1u
X80 a_8732_8406.t1 a_11060_8670.t1 VSS.t1 rhigh l=10u w=0.5u
X81 a_3073_1784.t1 a_4959_2048.t1 VSS.t174 rhigh l=9u w=0.5u
X82 VSS.t5 a_5838_7848.t0 VSS.t4 rhigh l=15.41u w=0.5u
X83 Vbg.t2 bgr_djalal_0.bgr_djalal_ota_1_stage_0.Vout1.t11 IOVDD.t186 IOVDD.t43 sg13_hv_pmos ad=0.17p pd=1.68u as=0.17p ps=1.68u w=0.5u l=3u
X84 VSS.t136 VSS.t45 VSS.t135 VSS.t64 sg13_hv_nmos ad=3.4p pd=20.68u as=0 ps=0 w=10u l=0.45u
X85 VSS.t162 IOVDD.t60 bgr_djalal_0.bgr_djalal_start_up_0.bgr_djalal_start_up_mirror_0.Iref.t4 IOVDD.t126 sg13_hv_pmos ad=0.68p pd=4.68u as=0.68p ps=4.68u w=2u l=1u
X86 VSS.t29 bgr_djalal_0.bgr_djalal_ota_1_stage_0.VN.t2 bgr_djalal_0.bgr_djalal_ota_1_stage_0.VN.t3 VSS.t28 sg13_hv_nmos ad=2.55p pd=15.68u as=2.55p ps=15.68u w=7.5u l=4u
X87 VSS.t88 ldo_brahim_0.ldo_brahim_opamp_2_stage_0/ldo_brahim_cs_0.VG.t7 ldo_brahim_0.ldo_brahim_pass_element2_0.VG2.t7 VSS.t182 sg13_hv_nmos ad=1.9p pd=10.38u as=1.9p ps=10.38u w=10u l=2u
X88 IOVDD.t221 bgr_djalal_0.bgr_djalal_ota_1_stage_0.Vout1.t7 cap_cmim l=7u w=7u
X89 a_4782_14426.t0 a_5046_11258.t1 VSS.t4 rhigh l=15.41u w=0.5u
X90 VDD.t26 ldo_brahim_0.ldo_brahim_pass_element2_0.VG2.t10 IOVDD.t195 VSS.t185 sg13_hv_nmos ad=1.9p pd=10.38u as=1.9p ps=10.38u w=10u l=0.45u
X91 bgr_djalal_0.bgr_djalal_ota_1_stage_0.bgr_djalal_ota_tail_0.tail.t4 bgr_djalal_0.bgr_djalal_ota_1_stage_0.VP.t4 bgr_djalal_0.bgr_djalal_ota_1_stage_0.bgr_djalal_ota_mirror_0.Iref.t1 IOVDD.t31 sg13_hv_pmos ad=3.4p pd=20.68u as=3.4p ps=20.68u w=10u l=5u
X92 VSS.t57 VSS.t43 VSS.t57 VSS.t30 sg13_hv_nmos ad=2.7p pd=8.22u as=0 ps=0 w=7.5u l=4u
X93 bgr_djalal_0.bgr_djalal_ota_1_stage_0.Vout1.t2 bgr_djalal_0.bgr_djalal_ota_1_stage_0.bgr_djalal_ota_mirror_0.Iref.t2 VSS.t16 VSS.t14 sg13_hv_nmos ad=0.34p pd=2.68u as=0.34p ps=2.68u w=1u l=10u
X94 IOVDD.t214 ldo_brahim_0.ldo_brahim_pass_element2_0.VG2.t10 VDD.t25 VSS.t187 sg13_hv_nmos ad=1.9p pd=10.38u as=3.4p ps=20.68u w=10u l=0.45u
X95 a_11302_8142.t0 a_13388_8406.t0 VSS.t1 rhigh l=10u w=0.5u
X96 VSS.t82 ldo_brahim_0.ldo_brahim_opamp_2_stage_0/ldo_brahim_cs_0.VG.t7 ldo_brahim_0.ldo_brahim_pass_element2_0.VG2.t6 VSS.t182 sg13_hv_nmos ad=1.9p pd=10.38u as=1.9p ps=10.38u w=10u l=2u
X97 bgr_djalal_0.bgr_djalal_ota_1_stage_0.bgr_djalal_ota_tail_0.tail.t3 ldo_brahim_0.I_Bias.t18 IOVDD.t23 IOVDD.t22 sg13_hv_pmos ad=1.9p pd=10.38u as=1.9p ps=10.38u w=10u l=2u
X98 ldo_brahim_0.I_Bias.t0 VSS.t131 ldo_brahim_0.I_Bias.t0 VSS.t64 sg13_hv_nmos ad=1.9p pd=10.38u as=0 ps=0 w=10u l=1u
X99 a_5838_14426.t0 VR.t0 VSS.t4 rhigh l=15.41u w=0.5u
X100 IOVDD.t192 ldo_brahim_0.ldo_brahim_pass_element2_0.VG2.t10 VDD.t14 VSS.t185 sg13_hv_nmos ad=1.9p pd=10.38u as=1.9p ps=10.38u w=10u l=0.45u
X101 IOVDD.t136 IOVDD.t61 IOVDD.t135 IOVDD.t62 sg13_hv_pmos ad=0.17p pd=1.68u as=0 ps=0 w=0.5u l=3u
X102 VDD.t24 ldo_brahim_0.ldo_brahim_pass_element2_0.VG2.t10 IOVDD.t196 VSS.t184 sg13_hv_nmos ad=1.9p pd=10.38u as=1.9p ps=10.38u w=10u l=0.45u
X103 IOVDD.t30 beta_multiplier_0.beta_multiplier_startup_0.beta_multiplier_startup_mirror_0.VS2.t0 beta_multiplier_0.beta_multiplier_startup_0.beta_multiplier_startup_enable_0.VS1.t1 IOVDD.t1 sg13_hv_pmos ad=1.7p pd=10.68u as=1.7p ps=10.68u w=5u l=1u
X104 a_6646_7878.t1 a_8732_7614.t0 VSS.t1 rhigh l=10u w=0.5u
X105 IOVDD.t194 ldo_brahim_0.ldo_brahim_pass_element2_0.VG2.t10 VDD.t21 VSS.t185 sg13_hv_nmos ad=1.9p pd=10.38u as=1.9p ps=10.38u w=10u l=0.45u
X106 VDD.t2 ldo_brahim_0.ldo_brahim_pass_element2_0.VG2.t10 IOVDD.t194 VSS.t185 sg13_hv_nmos ad=1.9p pd=10.38u as=1.9p ps=10.38u w=10u l=0.45u
X107 a_6646_7878.t0 a_8732_8142.t0 VSS.t1 rhigh l=10u w=0.5u
X108 IOVDD.t133 IOVDD.t53 IOVDD.t132 IOVDD.t3 sg13_hv_pmos ad=1.7p pd=10.68u as=0 ps=0 w=5u l=2u
X109 IOVDD.t11 ldo_brahim_0.I_Bias.t16 ldo_brahim_0.ldo_brahim_pass_element2_0.VG2.t3 IOVDD.t3 sg13_hv_pmos ad=1.9p pd=10.38u as=1.9p ps=10.38u w=10u l=2u
X110 IOVDD.t14 IOVDD.t129 IOVDD.t14 IOVDD.t130 sg13_hv_pmos ad=1.9p pd=10.38u as=0 ps=0 w=10u l=2u
X111 a_5046_11016.t0 a_4782_7848.t1 VSS.t4 rhigh l=15.41u w=0.5u
X112 VSS.t130 VSS.t127 VSS.t129 VSS.t128 sg13_hv_nmos ad=0.34p pd=2.68u as=0 ps=0 w=1u l=10u
X113 VSS.t126 VSS.t120 VSS.t125 VSS.t121 sg13_hv_nmos ad=1.9p pd=10.38u as=0 ps=0 w=10u l=2u
X114 a_8974_7878.t1 a_11060_7614.t1 VSS.t1 rhigh l=10u w=0.5u
X115 a_8974_7878.t0 a_11060_8142.t1 VSS.t1 rhigh l=10u w=0.5u
X116 IOVDD.t196 ldo_brahim_0.ldo_brahim_pass_element2_0.VG2.t10 VDD.t23 VSS.t184 sg13_hv_nmos ad=1.9p pd=10.38u as=3.4p ps=20.68u w=10u l=0.45u
X117 IOVDD.t128 IOVDD.t125 IOVDD.t127 IOVDD.t126 sg13_hv_pmos ad=0.68p pd=4.68u as=0 ps=0 w=2u l=1u
X118 IOVDD.t124 IOVDD.t94 IOVDD.t123 IOVDD.t1 sg13_hv_pmos ad=1.7p pd=10.68u as=0 ps=0 w=5u l=1u
X119 VSS.t123 VSS.t120 VSS.t122 VSS.t121 sg13_hv_nmos ad=1.9p pd=10.38u as=0 ps=0 w=10u l=2u
X120 IOVDD.t202 ldo_brahim_0.ldo_brahim_pass_element2_0.VG2.t10 VDD.t12 VSS.t188 sg13_hv_nmos ad=1.9p pd=10.38u as=1.9p ps=10.38u w=10u l=0.45u
X121 VSS.t119 VSS.t45 VSS.t118 VSS.t64 sg13_hv_nmos ad=3.4p pd=20.68u as=0 ps=0 w=10u l=0.45u
X122 bgr_djalal_0.bgr_djalal_ota_1_stage_0.Vout1.t4 bgr_djalal_0.bgr_djalal_start_up_0.bgr_djalal_start_up_enable_0.Icpy.t3 VSS.t24 VSS.t23 sg13_hv_nmos ad=1.36p pd=8.68u as=1.36p ps=8.68u w=4u l=2u
X123 VDD.t22 ldo_brahim_0.ldo_brahim_pass_element2_0.VG2.t10 IOVDD.t190 VSS.t185 sg13_hv_nmos ad=1.9p pd=10.38u as=1.9p ps=10.38u w=10u l=0.45u
X124 IOVDD.t200 ldo_brahim_0.ldo_brahim_pass_element2_0.VG2.t10 VDD.t11 VSS.t186 sg13_hv_nmos ad=1.9p pd=10.38u as=1.9p ps=10.38u w=10u l=0.45u
X125 bgr_djalal_0.bgr_djalal_resistors_0.VP1.t0 a_8732_7614.t1 VSS.t1 rhigh l=10u w=0.5u
X126 IOVDD.t190 ldo_brahim_0.ldo_brahim_pass_element2_0.VG2.t10 VDD.t18 VSS.t185 sg13_hv_nmos ad=1.9p pd=10.38u as=1.9p ps=10.38u w=10u l=0.45u
X127 IOVDD.t121 IOVDD.t119 IOVDD.t120 IOVDD.t1 sg13_hv_pmos ad=1.7p pd=10.68u as=0 ps=0 w=5u l=1u
X128 IOVDD.t118 IOVDD.t89 IOVDD.t117 IOVDD.t50 sg13_hv_pmos ad=3.4p pd=20.68u as=0 ps=0 w=10u l=5u
X129 IOVDD.t193 ldo_brahim_0.ldo_brahim_pass_element2_0.VG2.t10 VDD.t20 VSS.t185 sg13_hv_nmos ad=3.4p pd=20.68u as=1.9p ps=10.38u w=10u l=0.45u
X130 VSS.t116 VSS.t115 VSS.t116 VSS.t64 sg13_hv_nmos ad=1.9p pd=10.38u as=0 ps=0 w=10u l=1u
X131 VDD.t21 ldo_brahim_0.ldo_brahim_pass_element2_0.VG2.t10 IOVDD.t191 VSS.t185 sg13_hv_nmos ad=1.9p pd=10.38u as=1.9p ps=10.38u w=10u l=0.45u
X132 IOVDD.t93 IOVDD.t114 bgr_djalal_0.bgr_djalal_ota_1_stage_0.bgr_djalal_ota_tail_0.tail.t3 IOVDD.t50 sg13_hv_pmos ad=1.9p pd=10.38u as=1.9p ps=10.38u w=10u l=2u
X133 IOVDD.t113 IOVDD.t108 IOVDD.t112 IOVDD.t69 sg13_hv_pmos ad=0.68p pd=4.68u as=0 ps=0 w=2u l=1u
X134 bgr_djalal_0.bgr_djalal_resistors_0.VP1.t2 bgr_djalal_0.bgr_djalal_resistors_0.VP1.t1 VSS.t31 VSS.t30 sg13_hv_nmos ad=2.55p pd=15.68u as=2.7p ps=8.22u w=7.5u l=4u
X135 VSS.t39 ldo_brahim_0.ldo_brahim_opamp_2_stage_0/ldo_brahim_mirror_0.i_ref.t2 ldo_brahim_0.ldo_brahim_opamp_2_stage_0/ldo_brahim_cs_0.VG.t2 VSS.t37 sg13_hv_nmos ad=3.4p pd=20.68u as=3.4p ps=20.68u w=10u l=2u
X136 IOVDD.t110 IOVDD.t108 IOVDD.t109 IOVDD.t69 sg13_hv_pmos ad=0.68p pd=4.68u as=0 ps=0 w=2u l=1u
X137 bgr_djalal_0.bgr_djalal_start_up_0.bgr_djalal_start_up_enable_0.Icpy.t1 bgr_djalal_0.bgr_djalal_start_up_0.bgr_djalal_start_up_mirror_0.Iref.t0 IOVDD.t182 IOVDD.t43 sg13_hv_pmos ad=0.68p pd=4.68u as=0.68p ps=4.68u w=2u l=1u
X138 a_8974_7350.t0 a_11060_7614.t0 VSS.t1 rhigh l=10u w=0.5u
X139 VSS.t114 VSS.t111 VSS.t113 VSS.t112 sg13_hv_nmos ad=3.4p pd=20.68u as=0 ps=0 w=10u l=2u
X140 beta_multiplier_0.beta_multiplier_mirror_0.VN.t2 VSS.t105 VSS.t106 VSS.t64 sg13_hv_nmos ad=1.9p pd=10.38u as=3.4p ps=20.68u w=10u l=1u
X141 bgr_djalal_0.bgr_djalal_start_up_0.bgr_djalal_start_up_mirror_0.Iref.t2 bgr_djalal_0.bgr_djalal_start_up_0.bgr_djalal_start_up_mirror_0.Iref.t0 IOVDD.t181 IOVDD.t43 sg13_hv_pmos ad=0.68p pd=4.68u as=0.68p ps=4.68u w=2u l=1u
X142 ldo_brahim_0.ldo_brahim_pass_element2_0.VG2.t7 ldo_brahim_0.ldo_brahim_opamp_2_stage_0/ldo_brahim_cs_0.VG.t8 VSS.t173 VSS.t171 sg13_hv_nmos ad=1.9p pd=10.38u as=1.9p ps=10.38u w=10u l=2u
X143 VSS.t2 VSS.t3 VSS.t1 rhigh l=10u w=0.5u
X144 VDD.t20 ldo_brahim_0.ldo_brahim_pass_element2_0.VG2.t10 IOVDD.t192 VSS.t185 sg13_hv_nmos ad=1.9p pd=10.38u as=1.9p ps=10.38u w=10u l=0.45u
X145 bgr_djalal_0.bgr_djalal_ota_1_stage_0.bgr_djalal_ota_mirror_0.Iref.t4 bgr_djalal_0.bgr_djalal_ota_1_stage_0.bgr_djalal_ota_mirror_0.Iref.t2 VSS.t15 VSS.t14 sg13_hv_nmos ad=0.34p pd=2.68u as=0.34p ps=2.68u w=1u l=10u
X146 IOVDD.t191 ldo_brahim_0.ldo_brahim_pass_element2_0.VG2.t10 VDD.t19 VSS.t185 sg13_hv_nmos ad=1.9p pd=10.38u as=3.4p ps=20.68u w=10u l=0.45u
X147 a_5310_14426.t0 a_5046_11258.t0 VSS.t4 rhigh l=15.41u w=0.5u
X148 IOVDD.t222 bgr_djalal_0.bgr_djalal_ota_1_stage_0.Vout1.t8 cap_cmim l=7u w=7u
X149 IOVDD.t8 IOVDD.t87 IOVDD.t107 IOVDD.t3 sg13_hv_pmos ad=3.4p pd=20.68u as=0 ps=0 w=10u l=2u
X150 a_13630_7350.t1 a_15716_7350.t0 VSS.t0 rhigh l=10u w=0.5u
X151 IOVDD.t105 IOVDD.t100 IOVDD.t104 IOVDD.t57 sg13_hv_pmos ad=0.68p pd=4.68u as=0 ps=0 w=2u l=1u
X152 a_3073_1784.t0 VFB.t0 VSS.t34 rhigh l=9u w=0.5u
X153 IOVDD.t20 ldo_brahim_0.I_Bias.t17 ldo_brahim_0.ldo_brahim_pass_element2_0.VG2.t2 IOVDD.t3 sg13_hv_pmos ad=1.9p pd=10.38u as=1.9p ps=10.38u w=10u l=2u
X154 IOVDD.t102 IOVDD.t100 IOVDD.t101 IOVDD.t57 sg13_hv_pmos ad=0.68p pd=4.68u as=0 ps=0 w=2u l=1u
X155 VSS.t104 VSS.t43 VSS.t44 VSS.t56 sg13_hv_nmos ad=2.55p pd=15.68u as=0 ps=0 w=7.5u l=1u
X156 ldo_brahim_0.ldo_brahim_pass_element2_0.VG2.t6 ldo_brahim_0.ldo_brahim_opamp_2_stage_0/ldo_brahim_cs_0.VG.t8 VSS.t172 VSS.t171 sg13_hv_nmos ad=1.9p pd=10.38u as=1.9p ps=10.38u w=10u l=2u
X157 VDD.t18 ldo_brahim_0.ldo_brahim_pass_element2_0.VG2.t10 IOVDD.t189 VSS.t185 sg13_hv_nmos ad=1.9p pd=10.38u as=1.9p ps=10.38u w=10u l=0.45u
X158 IOVDD.t206 ldo_brahim_0.ldo_brahim_pass_element2_0.VG2.t10 VDD.t16 VSS.t188 sg13_hv_nmos ad=3.4p pd=20.68u as=1.9p ps=10.38u w=10u l=0.45u
X159 IOVDD.t99 IOVDD.t97 IOVDD.t98 IOVDD.t3 sg13_hv_pmos ad=1.7p pd=10.68u as=0 ps=0 w=5u l=2u
X160 IOVDD.t223 bgr_djalal_0.bgr_djalal_ota_1_stage_0.Vout1.t7 cap_cmim l=7u w=7u
X161 IOVDD.t205 ldo_brahim_0.ldo_brahim_pass_element2_0.VG2.t10 VDD.t15 VSS.t186 sg13_hv_nmos ad=3.4p pd=20.68u as=1.9p ps=10.38u w=10u l=0.45u
X162 IOVDD.t96 IOVDD.t94 IOVDD.t95 IOVDD.t1 sg13_hv_pmos ad=1.7p pd=10.68u as=0 ps=0 w=5u l=1u
X163 a_15716_7086.t1 VSS.t166 VSS.t8 rhigh l=10u w=0.5u
X164 a_11060_7086.t0 a_15716_7086.t0 VSS.t0 rhigh l=10u w=0.5u
X165 IOVDD.t221 bgr_djalal_0.bgr_djalal_ota_1_stage_0.Vout1.t6 cap_cmim l=7u w=7u
X166 a_4959_2576.t1 a_5183_1757.t2 VSS.t25 rhigh l=3u w=0.5u
X167 IOVDD.t93 IOVDD.t92 IOVDD.t93 IOVDD.t50 sg13_hv_pmos ad=1.9p pd=10.38u as=0 ps=0 w=10u l=2u
X168 ldo_brahim_0.ldo_brahim_opamp_2_stage_0/ldo_brahim_mirror_0.i_ref.t1 VFB.t2 ldo_brahim_0.ldo_brahim_opamp_2_stage_0/ldo_brahim_tail_0.tail.t5 IOVDD.t3 sg13_hv_pmos ad=1.7p pd=10.68u as=1.7p ps=10.68u w=5u l=2u
X169 VSS.t189 ldo_brahim_0.ldo_brahim_pass_element2_0.VG2.t4 cap_cmim l=27u w=45u
X170 IOVDD.t217 bgr_djalal_0.bgr_djalal_ota_1_stage_0.Vout1.t8 cap_cmim l=7u w=7u
X171 bgr_djalal_0.bgr_djalal_ota_1_stage_0.VP.t1 bgr_djalal_0.bgr_djalal_ota_1_stage_0.Vout1.t11 IOVDD.t185 IOVDD.t43 sg13_hv_pmos ad=0.17p pd=1.68u as=0.17p ps=1.68u w=0.5u l=3u
X172 a_4782_11016.t0 a_4782_7848.t0 VSS.t4 rhigh l=15.41u w=0.5u
X173 VSS.t95 VSS.t43 VSS.t95 VSS.t92 sg13_hv_nmos ad=2.7p pd=8.22u as=0 ps=0 w=7.5u l=1u
X174 IOVDD.t15 ldo_brahim_0.I_Bias.t1 beta_multiplier_0.beta_multiplier_mirror_0.VN.t1 IOVDD.t1 sg13_hv_pmos ad=0.95p pd=5.38u as=1.7p ps=10.68u w=5u l=2u
X175 IOVDD.t91 IOVDD.t89 IOVDD.t90 IOVDD.t50 sg13_hv_pmos ad=3.4p pd=20.68u as=0 ps=0 w=10u l=5u
X176 ldo_brahim_0.ldo_brahim_pass_element2_0.VG2.t3 ldo_brahim_0.I_Bias.t16 IOVDD.t18 IOVDD.t3 sg13_hv_pmos ad=1.9p pd=10.38u as=1.9p ps=10.38u w=10u l=2u
X177 IOVDD.t29 beta_multiplier_0.beta_multiplier_startup_0.beta_multiplier_startup_mirror_0.VS2.t0 beta_multiplier_0.beta_multiplier_startup_0.beta_multiplier_startup_mirror_0.VS2.t2 IOVDD.t1 sg13_hv_pmos ad=1.7p pd=10.68u as=1.7p ps=10.68u w=5u l=1u
X178 IOVDD.t189 ldo_brahim_0.ldo_brahim_pass_element2_0.VG2.t10 VDD.t17 VSS.t185 sg13_hv_nmos ad=1.9p pd=10.38u as=3.4p ps=20.68u w=10u l=0.45u
X179 VDD.t16 ldo_brahim_0.ldo_brahim_pass_element2_0.VG2.t10 IOVDD.t202 VSS.t188 sg13_hv_nmos ad=1.9p pd=10.38u as=1.9p ps=10.38u w=10u l=0.45u
X180 IOVDD.t5 ldo_brahim_0.I_Bias.t18 bgr_djalal_0.bgr_djalal_ota_1_stage_0.bgr_djalal_ota_tail_0.tail.t2 IOVDD.t17 sg13_hv_pmos ad=1.9p pd=10.38u as=1.9p ps=10.38u w=10u l=2u
X181 VSS.t26 VSS.t27 VSS.t8 rhigh l=10u w=0.5u
X182 VR.t12 beta_multiplier_0.beta_multiplier_mirror_0.VN.t4 ldo_brahim_0.I_Bias.t0 VSS.t64 sg13_hv_nmos ad=3.4p pd=20.68u as=1.9p ps=10.38u w=10u l=1u
X183 VDD.t15 ldo_brahim_0.ldo_brahim_pass_element2_0.VG2.t10 IOVDD.t200 VSS.t186 sg13_hv_nmos ad=1.9p pd=10.38u as=1.9p ps=10.38u w=10u l=0.45u
X184 IOVDD.t6 IOVDD.t87 IOVDD.t88 IOVDD.t3 sg13_hv_pmos ad=3.4p pd=20.68u as=0 ps=0 w=10u l=2u
X185 IOVDD.t224 bgr_djalal_0.bgr_djalal_ota_1_stage_0.Vout1.t7 cap_cmim l=7u w=7u
X186 a_11302_7614.t1 a_13388_7878.t1 VSS.t1 rhigh l=10u w=0.5u
X187 VDD.t0 VFB.t1 VSS.t161 rhigh l=9u w=0.5u
X188 IOVDD.t86 IOVDD.t65 IOVDD.t85 IOVDD.t33 sg13_hv_pmos ad=3.4p pd=20.68u as=0 ps=0 w=10u l=5u
X189 a_11302_8142.t1 a_13388_7878.t0 VSS.t1 rhigh l=10u w=0.5u
X190 IOVDD.t83 IOVDD.t36 IOVDD.t18 IOVDD.t3 sg13_hv_pmos ad=1.9p pd=10.38u as=0 ps=0 w=10u l=2u
X191 VSS.t99 VSS.t63 VSS.t98 VSS.t64 sg13_hv_nmos ad=3.4p pd=20.68u as=0 ps=0 w=10u l=0.45u
X192 VSS.t96 VSS.t43 VSS.t95 VSS.t32 sg13_hv_nmos ad=2.55p pd=15.68u as=0 ps=0 w=7.5u l=4u
X193 IOVDD.t80 IOVDD.t61 IOVDD.t79 IOVDD.t62 sg13_hv_pmos ad=0.17p pd=1.68u as=0 ps=0 w=0.5u l=3u
X194 ldo_brahim_0.I_Bias.t0 beta_multiplier_0.beta_multiplier_mirror_0.VN.t5 VR.t13 VSS.t64 sg13_hv_nmos ad=1.9p pd=10.38u as=3.4p ps=20.68u w=10u l=1u
X195 VSS.t90 VSS.t43 VSS.t90 VSS.t92 sg13_hv_nmos ad=2.7p pd=8.22u as=0 ps=0 w=7.5u l=1u
X196 VSS.t11 bgr_djalal_0.bgr_djalal_ota_1_stage_0.VN.t5 bgr_djalal_0.bgr_djalal_start_up_0.bgr_djalal_start_up_enable_0.Icpy.t2 VSS.t10 sg13_hv_nmos ad=1.36p pd=8.68u as=1.36p ps=8.68u w=4u l=2u
X197 VSS.t91 VSS.t43 VSS.t90 VSS.t32 sg13_hv_nmos ad=2.55p pd=15.68u as=0 ps=0 w=7.5u l=4u
X198 VSS.t88 VSS.t79 VSS.t87 VSS.t80 sg13_hv_nmos ad=3.4p pd=20.68u as=0 ps=0 w=10u l=2u
X199 IOVDD.t220 bgr_djalal_0.bgr_djalal_ota_1_stage_0.Vout1.t5 cap_cmim l=7u w=7u
X200 IOVDD.t198 ldo_brahim_0.ldo_brahim_pass_element2_0.VG2.t10 VDD.t10 VSS.t185 sg13_hv_nmos ad=1.9p pd=10.38u as=1.9p ps=10.38u w=10u l=0.45u
X201 VDD.t14 ldo_brahim_0.ldo_brahim_pass_element2_0.VG2.t10 IOVDD.t198 VSS.t185 sg13_hv_nmos ad=1.9p pd=10.38u as=1.9p ps=10.38u w=10u l=0.45u
X202 ldo_brahim_0.ldo_brahim_opamp_2_stage_0/ldo_brahim_tail_0.tail.t0 VFB.t3 ldo_brahim_0.ldo_brahim_opamp_2_stage_0/ldo_brahim_mirror_0.i_ref.t0 IOVDD.t3 sg13_hv_pmos ad=1.7p pd=10.68u as=1.7p ps=10.68u w=5u l=2u
X203 a_5310_14426.t1 a_5574_11258.t0 VSS.t4 rhigh l=15.41u w=0.5u
X204 IOVDD.t16 ldo_brahim_0.I_Bias.t16 ldo_brahim_0.ldo_brahim_pass_element2_0.VG2.t0 IOVDD.t3 sg13_hv_pmos ad=1.9p pd=10.38u as=1.9p ps=10.38u w=10u l=2u
X205 IOVDD.t77 IOVDD.t75 IOVDD.t76 IOVDD.t57 sg13_hv_pmos ad=0.17p pd=1.68u as=0 ps=0 w=0.5u l=3u
X206 VSS.t85 VSS.t43 VSS.t84 VSS.t28 sg13_hv_nmos ad=2.55p pd=15.68u as=0 ps=0 w=7.5u l=4u
X207 bgr_djalal_0.bgr_djalal_start_up_0.bgr_djalal_start_up_mirror_0.Iref.t5 VSS.t22 cap_cmim l=5u w=5u
X208 ldo_brahim_0.I_Bias.t4 ldo_brahim_0.I_Bias.t3 IOVDD.t15 IOVDD.t1 sg13_hv_pmos ad=1.7p pd=10.68u as=0.95p ps=5.38u w=5u l=2u
X209 bgr_djalal_0.bgr_djalal_ota_1_stage_0.bgr_djalal_ota_tail_0.tail.t2 ldo_brahim_0.I_Bias.t18 IOVDD.t14 IOVDD.t13 sg13_hv_pmos ad=1.9p pd=10.38u as=1.9p ps=10.38u w=10u l=2u
X210 bgr_djalal_0.bgr_djalal_ota_1_stage_0.VN.t1 bgr_djalal_0.bgr_djalal_ota_1_stage_0.Vout1.t11 IOVDD.t184 IOVDD.t43 sg13_hv_pmos ad=0.17p pd=1.68u as=0.17p ps=1.68u w=0.5u l=3u
X211 VSS.t82 VSS.t79 VSS.t81 VSS.t80 sg13_hv_nmos ad=3.4p pd=20.68u as=0 ps=0 w=10u l=2u
X212 VSS.t176 VR.t16 beta_multiplier_0.beta_multiplier_startup_0.beta_multiplier_startup_enable_0.VS1.t2 VSS.t64 sg13_hv_nmos ad=3.4p pd=20.68u as=3.4p ps=20.68u w=10u l=0.45u
X213 ldo_brahim_0.I_Bias.t15 VSS.t78 ldo_brahim_0.I_Bias.t15 VSS.t46 sg13_hv_nmos ad=1.9p pd=10.38u as=0 ps=0 w=10u l=1u
X214 a_11302_7614.t0 a_13388_7350.t0 VSS.t1 rhigh l=10u w=0.5u
X215 VSS.t77 VSS.t43 VSS.t76 VSS.t28 sg13_hv_nmos ad=2.55p pd=15.68u as=0 ps=0 w=7.5u l=4u
X216 IOVDD.t74 IOVDD.t49 IOVDD.t73 IOVDD.t50 sg13_hv_pmos ad=3.4p pd=20.68u as=0 ps=0 w=10u l=5u
X217 IOVDD.t9 ldo_brahim_0.I_Bias.t1 ldo_brahim_0.I_Bias.t2 IOVDD.t1 sg13_hv_pmos ad=0.95p pd=5.38u as=1.7p ps=10.68u w=5u l=2u
X218 a_13388_8406.t1 a_15716_8142.t0 VSS.t0 rhigh l=10u w=0.5u
X219 IOVDD.t203 ldo_brahim_0.ldo_brahim_pass_element2_0.VG2.t10 VDD.t13 VSS.t187 sg13_hv_nmos ad=1.9p pd=10.38u as=1.9p ps=10.38u w=10u l=0.45u
X220 IOVDD.t183 bgr_djalal_0.bgr_djalal_ota_1_stage_0.Vout1.t11 bgr_djalal_0.bgr_djalal_ota_1_stage_0.VN.t0 IOVDD.t126 sg13_hv_pmos ad=0.17p pd=1.68u as=0.17p ps=1.68u w=0.5u l=3u
X221 a_5574_11016.t0 a_5310_7848.t1 VSS.t4 rhigh l=15.41u w=0.5u
X222 VSS.t74 VSS.t71 VSS.t73 VSS.t72 sg13_hv_nmos ad=0.68p pd=4.68u as=0 ps=0 w=2u l=2.75u
X223 VDD.t12 ldo_brahim_0.ldo_brahim_pass_element2_0.VG2.t10 IOVDD.t201 VSS.t188 sg13_hv_nmos ad=1.9p pd=10.38u as=1.9p ps=10.38u w=10u l=0.45u
X224 VSS.t70 VSS.t67 VSS.t69 VSS.t68 sg13_hv_nmos ad=1.36p pd=8.68u as=0 ps=0 w=4u l=2u
X225 a_6646_7350.t1 a_8732_7350.t0 VSS.t1 rhigh l=10u w=0.5u
X226 IOVDD.t201 ldo_brahim_0.ldo_brahim_pass_element2_0.VG2.t10 VDD.t7 VSS.t188 sg13_hv_nmos ad=1.9p pd=10.38u as=1.9p ps=10.38u w=10u l=0.45u
X227 ldo_brahim_0.ldo_brahim_pass_element2_0.VG2.t2 ldo_brahim_0.I_Bias.t17 IOVDD.t11 IOVDD.t3 sg13_hv_pmos ad=1.9p pd=10.38u as=1.9p ps=10.38u w=10u l=2u
X228 IOVDD.t71 IOVDD.t68 IOVDD.t70 IOVDD.t69 sg13_hv_pmos ad=0.68p pd=4.68u as=0 ps=0 w=2u l=1u
X229 IOVDD.t67 IOVDD.t65 IOVDD.t66 IOVDD.t33 sg13_hv_pmos ad=3.4p pd=20.68u as=0 ps=0 w=10u l=5u
X230 VSS.t173 ldo_brahim_0.ldo_brahim_opamp_2_stage_0/ldo_brahim_cs_0.VG.t5 ldo_brahim_0.ldo_brahim_pass_element2_0.VG2.t9 VSS.t178 sg13_hv_nmos ad=1.9p pd=10.38u as=1.9p ps=10.38u w=10u l=2u
X231 VDD.t11 ldo_brahim_0.ldo_brahim_pass_element2_0.VG2.t10 IOVDD.t199 VSS.t186 sg13_hv_nmos ad=1.9p pd=10.38u as=1.9p ps=10.38u w=10u l=0.45u
X232 IOVDD.t10 ldo_brahim_0.I_Bias.t16 ldo_brahim_0.ldo_brahim_opamp_2_stage_0/ldo_brahim_tail_0.tail.t2 IOVDD.t3 sg13_hv_pmos ad=1.9p pd=10.38u as=1.9p ps=10.38u w=10u l=2u
X233 bgr_djalal_0.bgr_djalal_ota_1_stage_0.bgr_djalal_ota_mirror_0.Iref.t0 bgr_djalal_0.bgr_djalal_ota_1_stage_0.VP.t5 bgr_djalal_0.bgr_djalal_ota_1_stage_0.bgr_djalal_ota_tail_0.tail.t0 IOVDD.t0 sg13_hv_pmos ad=3.4p pd=20.68u as=3.4p ps=20.68u w=10u l=5u
X234 VDD.t10 ldo_brahim_0.ldo_brahim_pass_element2_0.VG2.t10 IOVDD.t197 VSS.t185 sg13_hv_nmos ad=1.9p pd=10.38u as=1.9p ps=10.38u w=10u l=0.45u
X235 IOVDD.t199 ldo_brahim_0.ldo_brahim_pass_element2_0.VG2.t10 VDD.t6 VSS.t186 sg13_hv_nmos ad=1.9p pd=10.38u as=1.9p ps=10.38u w=10u l=0.45u
X236 IOVDD.t64 IOVDD.t61 IOVDD.t63 IOVDD.t62 sg13_hv_pmos ad=0.17p pd=1.68u as=0 ps=0 w=0.5u l=3u
X237 bgr_djalal_0.bgr_djalal_start_up_0.bgr_djalal_start_up_mirror_0.Iref.t3 IOVDD.t60 VSS.t163 IOVDD.t43 sg13_hv_pmos ad=0.68p pd=4.68u as=0.68p ps=4.68u w=2u l=1u
X238 a_15716_8670.t0 bgr_djalal_0.bgr_djalal_ota_1_stage_0.VP.t0 VSS.t8 rhigh l=10u w=0.5u
X239 VSS.t38 ldo_brahim_0.ldo_brahim_opamp_2_stage_0/ldo_brahim_mirror_0.i_ref.t2 ldo_brahim_0.ldo_brahim_opamp_2_stage_0/ldo_brahim_mirror_0.i_ref.t4 VSS.t37 sg13_hv_nmos ad=3.4p pd=20.68u as=3.4p ps=20.68u w=10u l=2u
X240 beta_multiplier_0.beta_multiplier_startup_0.beta_multiplier_startup_mirror_0.VS2.t1 beta_multiplier_0.beta_multiplier_startup_0.beta_multiplier_startup_mirror_0.VS2.t0 IOVDD.t28 IOVDD.t1 sg13_hv_pmos ad=1.7p pd=10.68u as=1.7p ps=10.68u w=5u l=1u
X241 VSS.t66 VSS.t63 VSS.t65 VSS.t64 sg13_hv_nmos ad=3.4p pd=20.68u as=0 ps=0 w=10u l=0.45u
X242 a_8974_7350.t1 a_11060_7350.t1 VSS.t1 rhigh l=10u w=0.5u
X243 VSS.t169 VSS.t170 VSS.t1 rhigh l=10u w=0.5u
X244 VSS.t20 Vbg.t0 Vbg.t1 VSS.t19 sg13_hv_nmos ad=0.68p pd=4.68u as=0.68p ps=4.68u w=2u l=2.75u
X245 beta_multiplier_0.beta_multiplier_startup_0.beta_multiplier_startup_enable_0.VS1.t3 VR.t16 VSS.t175 VSS.t64 sg13_hv_nmos ad=3.4p pd=20.68u as=3.4p ps=20.68u w=10u l=0.45u
X246 VSS.t172 ldo_brahim_0.ldo_brahim_opamp_2_stage_0/ldo_brahim_cs_0.VG.t5 ldo_brahim_0.ldo_brahim_pass_element2_0.VG2.t8 VSS.t178 sg13_hv_nmos ad=1.9p pd=10.38u as=1.9p ps=10.38u w=10u l=2u
X247 VSS.t62 VSS.t59 VSS.t61 VSS.t60 sg13_hv_nmos ad=3.4p pd=20.68u as=0 ps=0 w=10u l=2u
X248 VSS.t58 VSS.t43 VSS.t57 VSS.t56 sg13_hv_nmos ad=2.55p pd=15.68u as=0 ps=0 w=7.5u l=1u
X249 IOVDD.t197 ldo_brahim_0.ldo_brahim_pass_element2_0.VG2.t10 VDD.t9 VSS.t185 sg13_hv_nmos ad=1.9p pd=10.38u as=3.4p ps=20.68u w=10u l=0.45u
X250 IOVDD.t59 IOVDD.t56 IOVDD.t58 IOVDD.t57 sg13_hv_pmos ad=0.68p pd=4.68u as=0 ps=0 w=2u l=1u
X251 beta_multiplier_0.beta_multiplier_mirror_0.VN.t0 ldo_brahim_0.I_Bias.t3 IOVDD.t9 IOVDD.t1 sg13_hv_pmos ad=1.7p pd=10.68u as=0.95p ps=5.38u w=5u l=2u
X252 VR.t4 beta_multiplier_0.beta_multiplier_startup_0.beta_multiplier_startup_enable_0.VS1.t5 ldo_brahim_0.I_Bias.t14 VSS.t64 sg13_hv_nmos ad=3.4p pd=20.68u as=3.4p ps=20.68u w=10u l=0.45u
X253 a_8732_7350.t1 a_11060_7086.t1 VSS.t1 rhigh l=10u w=0.5u
X254 ldo_brahim_0.ldo_brahim_opamp_2_stage_0/ldo_brahim_mirror_0.i_ref.t3 ldo_brahim_0.ldo_brahim_opamp_2_stage_0/ldo_brahim_mirror_0.i_ref.t2 VSS.t36 VSS.t35 sg13_hv_nmos ad=3.4p pd=20.68u as=3.4p ps=20.68u w=10u l=2u
X255 IOVDD.t55 IOVDD.t53 IOVDD.t54 IOVDD.t3 sg13_hv_pmos ad=1.7p pd=10.68u as=0 ps=0 w=5u l=2u
X256 IOVDD.t210 ldo_brahim_0.ldo_brahim_pass_element2_0.VG2.t10 VDD.t8 VSS.t184 sg13_hv_nmos ad=1.9p pd=10.38u as=1.9p ps=10.38u w=10u l=0.45u
X257 IOVDD.t8 ldo_brahim_0.I_Bias.t17 ldo_brahim_0.ldo_brahim_pass_element2_0.VG2.t1 IOVDD.t3 sg13_hv_pmos ad=1.9p pd=10.38u as=1.9p ps=10.38u w=10u l=2u
X258 VR.t3 beta_multiplier_0.beta_multiplier_startup_0.beta_multiplier_startup_enable_0.VS1.t5 ldo_brahim_0.I_Bias.t11 VSS.t46 sg13_hv_nmos ad=3.4p pd=20.68u as=3.4p ps=20.68u w=10u l=0.45u
X259 VSS.t55 VSS.t52 VSS.t54 VSS.t53 sg13_hv_nmos ad=1.36p pd=8.68u as=0 ps=0 w=4u l=2u
X260 a_4782_14426.t1 a_4782_11016.t1 VSS.t4 rhigh l=15.41u w=0.5u
X261 IOVDD.t223 bgr_djalal_0.bgr_djalal_ota_1_stage_0.Vout1.t6 cap_cmim l=7u w=7u
X262 VDD.t7 ldo_brahim_0.ldo_brahim_pass_element2_0.VG2.t10 IOVDD.t209 VSS.t188 sg13_hv_nmos ad=1.9p pd=10.38u as=1.9p ps=10.38u w=10u l=0.45u
X263 IOVDD.t52 IOVDD.t49 IOVDD.t51 IOVDD.t50 sg13_hv_pmos ad=3.4p pd=20.68u as=0 ps=0 w=10u l=5u
X264 IOVDD.t208 ldo_brahim_0.ldo_brahim_pass_element2_0.VG2.t10 VDD.t4 VSS.t187 sg13_hv_nmos ad=3.4p pd=20.68u as=1.9p ps=10.38u w=10u l=0.45u
X265 ldo_brahim_0.I_Bias.t7 beta_multiplier_0.beta_multiplier_startup_0.beta_multiplier_startup_enable_0.VS1.t4 VR.t2 VSS.t64 sg13_hv_nmos ad=3.4p pd=20.68u as=3.4p ps=20.68u w=10u l=0.45u
X266 VDD.t6 ldo_brahim_0.ldo_brahim_pass_element2_0.VG2.t10 IOVDD.t207 VSS.t186 sg13_hv_nmos ad=1.9p pd=10.38u as=1.9p ps=10.38u w=10u l=0.45u
X267 VSS.t51 VSS.t49 VSS.t50 VSS.t12 sg13_hv_nmos ad=0.34p pd=2.68u as=0 ps=0 w=1u l=10u
X268 IOVDD.t48 IOVDD.t42 IOVDD.t47 IOVDD.t43 sg13_hv_pmos ad=0.68p pd=4.68u as=0 ps=0 w=2u l=1u
X269 VSS.t13 bgr_djalal_0.bgr_djalal_ota_1_stage_0.bgr_djalal_ota_mirror_0.Iref.t2 bgr_djalal_0.bgr_djalal_ota_1_stage_0.bgr_djalal_ota_mirror_0.Iref.t3 VSS.t12 sg13_hv_nmos ad=0.34p pd=2.68u as=0.34p ps=2.68u w=1u l=10u
X270 ldo_brahim_0.ldo_brahim_pass_element2_0.VG2.t0 ldo_brahim_0.I_Bias.t16 IOVDD.t7 IOVDD.t3 sg13_hv_pmos ad=1.9p pd=10.38u as=1.9p ps=10.38u w=10u l=2u
X271 IOVDD.t45 IOVDD.t42 IOVDD.t44 IOVDD.t43 sg13_hv_pmos ad=0.68p pd=4.68u as=0 ps=0 w=2u l=1u
X272 bgr_djalal_0.bgr_djalal_ota_1_stage_0.Vout1.t1 bgr_djalal_0.bgr_djalal_ota_1_stage_0.VN.t6 bgr_djalal_0.bgr_djalal_ota_1_stage_0.bgr_djalal_ota_tail_0.tail.t5 IOVDD.t0 sg13_hv_pmos ad=3.4p pd=20.68u as=3.4p ps=20.68u w=10u l=5u
X273 IOVDD.t180 bgr_djalal_0.bgr_djalal_start_up_0.bgr_djalal_start_up_mirror_0.Iref.t0 bgr_djalal_0.bgr_djalal_start_up_0.bgr_djalal_start_up_mirror_0.Iref.t1 IOVDD.t126 sg13_hv_pmos ad=0.68p pd=4.68u as=0.68p ps=4.68u w=2u l=1u
X274 VSS.t48 VSS.t45 VSS.t47 VSS.t46 sg13_hv_nmos ad=3.4p pd=20.68u as=0 ps=0 w=10u l=0.45u
X275 VSS.t44 VSS.t43 VSS.t44 VSS.t30 sg13_hv_nmos ad=2.7p pd=8.22u as=0 ps=0 w=7.5u l=4u
X276 IOVDD.t224 bgr_djalal_0.bgr_djalal_ota_1_stage_0.Vout1.t6 cap_cmim l=7u w=7u
X277 IOVDD.t209 ldo_brahim_0.ldo_brahim_pass_element2_0.VG2.t10 VDD.t5 VSS.t188 sg13_hv_nmos ad=1.9p pd=10.38u as=3.4p ps=20.68u w=10u l=0.45u
X278 VDD.t4 ldo_brahim_0.ldo_brahim_pass_element2_0.VG2.t10 IOVDD.t203 VSS.t187 sg13_hv_nmos ad=1.9p pd=10.38u as=1.9p ps=10.38u w=10u l=0.45u
X279 IOVDD.t179 bgr_djalal_0.bgr_djalal_start_up_0.bgr_djalal_start_up_mirror_0.Iref.t0 bgr_djalal_0.bgr_djalal_start_up_0.bgr_djalal_start_up_enable_0.Icpy.t0 IOVDD.t126 sg13_hv_pmos ad=0.68p pd=4.68u as=0.68p ps=4.68u w=2u l=1u
X280 a_11060_8670.t0 a_15716_8670.t1 VSS.t0 rhigh l=10u w=0.5u
X281 IOVDD.t207 ldo_brahim_0.ldo_brahim_pass_element2_0.VG2.t10 VDD.t3 VSS.t186 sg13_hv_nmos ad=1.9p pd=10.38u as=3.4p ps=20.68u w=10u l=0.45u
X282 IOVDD.t6 ldo_brahim_0.I_Bias.t17 ldo_brahim_0.ldo_brahim_opamp_2_stage_0/ldo_brahim_tail_0.tail.t1 IOVDD.t3 sg13_hv_pmos ad=1.9p pd=10.38u as=1.9p ps=10.38u w=10u l=2u
X283 IOVDD.t41 IOVDD.t39 IOVDD.t40 IOVDD.t1 sg13_hv_pmos ad=1.7p pd=10.68u as=0 ps=0 w=5u l=1u
X284 VR.t14 beta_multiplier_0.beta_multiplier_mirror_0.VN.t6 ldo_brahim_0.I_Bias.t15 VSS.t46 sg13_hv_nmos ad=3.4p pd=20.68u as=1.9p ps=10.38u w=10u l=1u
X285 IOVDD.t38 IOVDD.t36 IOVDD.t7 IOVDD.t3 sg13_hv_pmos ad=1.9p pd=10.38u as=0 ps=0 w=10u l=2u
X286 bgr_djalal_0.bgr_djalal_ota_1_stage_0.bgr_djalal_ota_tail_0.tail.t1 ldo_brahim_0.I_Bias.t18 IOVDD.t5 IOVDD.t4 sg13_hv_pmos ad=1.9p pd=10.38u as=1.9p ps=10.38u w=10u l=2u
X287 IOVDD.t35 IOVDD.t32 IOVDD.t34 IOVDD.t33 sg13_hv_pmos ad=3.4p pd=20.68u as=0 ps=0 w=10u l=5u
X288 IOVDD.t222 bgr_djalal_0.bgr_djalal_ota_1_stage_0.Vout1.t5 cap_cmim l=7u w=7u
X289 IOVDD.t213 ldo_brahim_0.ldo_brahim_pass_element2_0.VG2.t10 VDD.t2 VSS.t185 sg13_hv_nmos ad=1.9p pd=10.38u as=1.9p ps=10.38u w=10u l=0.45u
X290 ldo_brahim_0.I_Bias.t9 beta_multiplier_0.beta_multiplier_startup_0.beta_multiplier_startup_enable_0.VS1.t5 VR.t1 VSS.t46 sg13_hv_nmos ad=3.4p pd=20.68u as=3.4p ps=20.68u w=10u l=0.45u
X291 VSS.t164 VSS.t165 VSS.t8 rhigh l=10u w=0.5u
X292 IOVDD.t212 ldo_brahim_0.ldo_brahim_pass_element2_0.VG2.t10 VDD.t1 VSS.t184 sg13_hv_nmos ad=3.4p pd=20.68u as=1.9p ps=10.38u w=10u l=0.45u
C0 ldo_brahim_0.I_Bias beta_multiplier_0.beta_multiplier_mirror_0.VN 6.82753f
C1 a_3159_1784# VFB 0.02329f
C2 bgr_djalal_0.bgr_djalal_ota_1_stage_0.VP IOVDD 12.4602f
C3 bgr_djalal_0.bgr_djalal_ota_1_stage_0.bgr_djalal_ota_tail_0.tail bgr_djalal_0.bgr_djalal_ota_1_stage_0.VN 0.65748f
C4 ldo_brahim_0.ldo_brahim_opamp_2_stage_0/ldo_brahim_cs_0.VG VDD 0.69327f
C5 bgr_djalal_0.bgr_djalal_ota_1_stage_0.bgr_djalal_ota_mirror_0.Iref IOVDD 1.80607f
C6 ldo_brahim_0.ldo_brahim_opamp_2_stage_0/ldo_brahim_tail_0.tail Vbg 0.46298f
C7 bgr_djalal_0.bgr_djalal_ota_1_stage_0.VP bgr_djalal_0.bgr_djalal_resistors_0.VP1 0.86902f
C8 ldo_brahim_0.ldo_brahim_opamp_2_stage_0/ldo_brahim_cs_0.VG IOVDD 2.05074f
C9 a_6732_8670# a_6732_8406# 0.14652f
C10 ldo_brahim_0.ldo_brahim_opamp_2_stage_0/ldo_brahim_tail_0.tail VFB 0.42476f
C11 bgr_djalal_0.bgr_djalal_resistors_0.VP1 a_9060_7614# 0.01773f
C12 bgr_djalal_0.bgr_djalal_resistors_0.VP1 a_6732_7350# 0.03499f
C13 bgr_djalal_0.bgr_djalal_ota_1_stage_0.VN Vbg 0.27176f
C14 bgr_djalal_0.bgr_djalal_resistors_0.VP1 a_16044_7350# 0.0456f
C15 bgr_djalal_0.bgr_djalal_resistors_0.VP1 ldo_brahim_0.ldo_brahim_opamp_2_stage_0/ldo_brahim_cs_0.VG 0.04212f
C16 a_11388_8406# a_11388_8142# 0.14652f
C17 a_16044_8670# Vbg 0.01254f
C18 ldo_brahim_0.I_Bias a_4782_11344# 0.01866f
C19 ldo_brahim_0.ldo_brahim_pass_element2_0.VG2 ldo_brahim_0.ldo_brahim_opamp_2_stage_0/ldo_brahim_mirror_0.i_ref 0.15587f
C20 a_16044_8142# a_16044_7878# 0.14652f
C21 ldo_brahim_0.I_Bias a_5046_7934# 0.03055f
C22 a_9060_7878# a_9060_7614# 0.14652f
C23 ldo_brahim_0.I_Bias a_6102_7934# 0.08216f
C24 bgr_djalal_0.bgr_djalal_ota_1_stage_0.VP bgr_djalal_0.bgr_djalal_start_up_0.bgr_djalal_start_up_mirror_0.Iref 0.05603f
C25 beta_multiplier_0.beta_multiplier_startup_0.beta_multiplier_startup_enable_0.VS1 ldo_brahim_0.I_Bias 4.05284f
C26 bgr_djalal_0.bgr_djalal_ota_1_stage_0.Vout1 a_6102_11344# 0.04638f
C27 a_9060_7350# a_9060_7086# 0.14652f
C28 ldo_brahim_0.I_Bias IOVDD 52.6056f
C29 a_5574_11344# IOVDD 0.01555f
C30 ldo_brahim_0.I_Bias bgr_djalal_0.bgr_djalal_resistors_0.VP1 0.31209f
C31 a_13716_7086# IOVDD 0.0504f
C32 bgr_djalal_0.bgr_djalal_resistors_0.VP1 a_6732_7614# 0.03649f
C33 a_13716_8670# a_13716_8406# 0.14652f
C34 ldo_brahim_0.I_Bias VR 9.68565f
C35 bgr_djalal_0.bgr_djalal_resistors_0.VP1 a_13716_7350# 0.03407f
C36 bgr_djalal_0.bgr_djalal_resistors_0.VP1 a_13716_7086# 0.06782f
C37 a_5574_11344# VR 0.03771f
C38 a_13716_8406# a_13716_8142# 0.14652f
C39 a_6732_8142# a_6732_7878# 0.14652f
C40 ldo_brahim_0.ldo_brahim_opamp_2_stage_0/ldo_brahim_cs_0.VG ldo_brahim_0.ldo_brahim_opamp_2_stage_0/ldo_brahim_mirror_0.i_ref 3.85502f
C41 a_5310_11344# a_5574_11344# 0.2258f
C42 ldo_brahim_0.I_Bias a_5838_7934# 0.04194f
C43 a_16044_7878# a_16044_7614# 0.14652f
C44 a_4782_7934# a_5046_7934# 0.2258f
C45 bgr_djalal_0.bgr_djalal_ota_1_stage_0.bgr_djalal_ota_tail_0.tail IOVDD 3.1581f
C46 a_9060_7614# a_9060_7350# 0.14652f
C47 bgr_djalal_0.bgr_djalal_ota_1_stage_0.VN bgr_djalal_0.bgr_djalal_start_up_0.bgr_djalal_start_up_enable_0.Icpy 0.20277f
C48 bgr_djalal_0.bgr_djalal_ota_1_stage_0.Vout1 bgr_djalal_0.bgr_djalal_ota_1_stage_0.VP 4.85405f
C49 a_13716_7614# a_13716_7350# 0.14652f
C50 beta_multiplier_0.beta_multiplier_startup_0.beta_multiplier_startup_mirror_0.VS2 beta_multiplier_0.beta_multiplier_mirror_0.VN 0.03168f
C51 a_16044_7350# ldo_brahim_0.ldo_brahim_pass_element2_0.VG2 0.01096f
C52 a_9060_7350# ldo_brahim_0.ldo_brahim_opamp_2_stage_0/ldo_brahim_cs_0.VG 0.01164f
C53 bgr_djalal_0.bgr_djalal_ota_1_stage_0.Vout1 bgr_djalal_0.bgr_djalal_ota_1_stage_0.bgr_djalal_ota_mirror_0.Iref 5.5146f
C54 ldo_brahim_0.ldo_brahim_opamp_2_stage_0/ldo_brahim_cs_0.VG ldo_brahim_0.ldo_brahim_pass_element2_0.VG2 6.30299f
C55 a_9060_7086# ldo_brahim_0.ldo_brahim_opamp_2_stage_0/ldo_brahim_cs_0.VG 0.01319f
C56 Vbg VDD 0.0118f
C57 a_3159_1520# VFB 0.02435f
C58 beta_multiplier_0.beta_multiplier_mirror_0.VN a_5046_11344# 0.01643f
C59 a_3159_2576# a_3159_2312# 0.13187f
C60 IOVDD Vbg 16.3676f
C61 a_3159_1784# a_3159_1520# 0.13187f
C62 IOVDD VFB 2.94183f
C63 a_3159_1784# VDD 0.01022f
C64 bgr_djalal_0.bgr_djalal_resistors_0.VP1 a_16044_7878# 0.01851f
C65 bgr_djalal_0.bgr_djalal_resistors_0.VP1 Vbg 0.36669f
C66 a_9060_8406# a_9060_8142# 0.14652f
C67 ldo_brahim_0.ldo_brahim_opamp_2_stage_0/ldo_brahim_tail_0.tail IOVDD 1.55553f
C68 a_13716_8142# a_13716_7878# 0.14652f
C69 a_4782_11344# a_5046_11344# 0.2258f
C70 ldo_brahim_0.I_Bias a_6102_11344# 0.01546f
C71 a_6732_7878# a_6732_7614# 0.14652f
C72 beta_multiplier_0.beta_multiplier_startup_0.beta_multiplier_startup_mirror_0.VS2 beta_multiplier_0.beta_multiplier_startup_0.beta_multiplier_startup_enable_0.VS1 1.50415f
C73 ldo_brahim_0.I_Bias ldo_brahim_0.ldo_brahim_pass_element2_0.VG2 6.82865f
C74 bgr_djalal_0.bgr_djalal_ota_1_stage_0.VP bgr_djalal_0.bgr_djalal_ota_1_stage_0.bgr_djalal_ota_mirror_0.Iref 0.79933f
C75 bgr_djalal_0.bgr_djalal_ota_1_stage_0.VN IOVDD 12.9511f
C76 ldo_brahim_0.I_Bias bgr_djalal_0.bgr_djalal_ota_1_stage_0.Vout1 1.02187f
C77 a_5574_7934# a_5838_7934# 0.2258f
C78 bgr_djalal_0.bgr_djalal_ota_1_stage_0.Vout1 a_5574_11344# 0.0144f
C79 beta_multiplier_0.beta_multiplier_startup_0.beta_multiplier_startup_mirror_0.VS2 IOVDD 3.81506f
C80 a_9060_7614# ldo_brahim_0.ldo_brahim_opamp_2_stage_0/ldo_brahim_cs_0.VG 0.01004f
C81 a_13716_7350# ldo_brahim_0.ldo_brahim_pass_element2_0.VG2 0.01096f
C82 a_6732_7350# ldo_brahim_0.ldo_brahim_opamp_2_stage_0/ldo_brahim_cs_0.VG 0.01164f
C83 bgr_djalal_0.bgr_djalal_ota_1_stage_0.VN bgr_djalal_0.bgr_djalal_resistors_0.VP1 1.81025f
C84 a_13716_7086# ldo_brahim_0.ldo_brahim_pass_element2_0.VG2 0.01733f
C85 ldo_brahim_0.ldo_brahim_pass_element2_0.VG2 a_2835_1843# 0.03908f
C86 a_5183_1843# VFB 0.02584f
C87 beta_multiplier_0.beta_multiplier_mirror_0.VN a_4782_11344# 0.03643f
C88 a_5838_11344# IOVDD 0.01798f
C89 bgr_djalal_0.bgr_djalal_resistors_0.VP1 a_16044_8142# 0.01478f
C90 beta_multiplier_0.beta_multiplier_startup_0.beta_multiplier_startup_mirror_0.VS2 VR 0.04897f
C91 bgr_djalal_0.bgr_djalal_resistors_0.VP1 a_13716_7878# 0.01017f
C92 a_5046_11344# VR 0.02088f
C93 a_5838_11344# VR 0.06207f
C94 ldo_brahim_0.ldo_brahim_opamp_2_stage_0/ldo_brahim_mirror_0.i_ref Vbg 0.07764f
C95 beta_multiplier_0.beta_multiplier_mirror_0.VN IOVDD 1.30322f
C96 bgr_djalal_0.bgr_djalal_ota_1_stage_0.VP a_16044_8406# 0.03468f
C97 bgr_djalal_0.bgr_djalal_start_up_0.bgr_djalal_start_up_enable_0.Icpy IOVDD 0.8827f
C98 bgr_djalal_0.bgr_djalal_ota_1_stage_0.bgr_djalal_ota_tail_0.tail bgr_djalal_0.bgr_djalal_ota_1_stage_0.Vout1 0.19705f
C99 ldo_brahim_0.I_Bias bgr_djalal_0.bgr_djalal_ota_1_stage_0.VP 0.03079f
C100 bgr_djalal_0.bgr_djalal_ota_1_stage_0.bgr_djalal_ota_mirror_0.Iref a_11388_8670# 0.05126f
C101 ldo_brahim_0.ldo_brahim_opamp_2_stage_0/ldo_brahim_mirror_0.i_ref VFB 0.30077f
C102 a_5046_11344# a_5310_11344# 0.2258f
C103 ldo_brahim_0.I_Bias a_5310_7934# 0.02536f
C104 a_13716_7878# a_13716_7614# 0.14652f
C105 ldo_brahim_0.I_Bias ldo_brahim_0.ldo_brahim_opamp_2_stage_0/ldo_brahim_cs_0.VG 0.03743f
C106 a_6732_7614# a_6732_7350# 0.14652f
C107 a_11388_7614# a_11388_7350# 0.14652f
C108 ldo_brahim_0.ldo_brahim_pass_element2_0.VG2 Vbg 0.57726f
C109 a_6732_7614# ldo_brahim_0.ldo_brahim_opamp_2_stage_0/ldo_brahim_cs_0.VG 0.01004f
C110 bgr_djalal_0.bgr_djalal_ota_1_stage_0.Vout1 Vbg 1.72667f
C111 beta_multiplier_0.beta_multiplier_mirror_0.VN VR 1.81178f
C112 ldo_brahim_0.ldo_brahim_pass_element2_0.VG2 VFB 5.87535f
C113 ldo_brahim_0.ldo_brahim_opamp_2_stage_0/ldo_brahim_mirror_0.i_ref ldo_brahim_0.ldo_brahim_opamp_2_stage_0/ldo_brahim_tail_0.tail 0.25393f
C114 ldo_brahim_0.ldo_brahim_pass_element2_0.VG2 a_3159_2576# 0.0157f
C115 a_3159_2048# a_3159_1784# 0.13187f
C116 a_3159_1520# VDD 0.07677f
C117 a_16044_7086# IOVDD 0.06702f
C118 bgr_djalal_0.bgr_djalal_start_up_0.bgr_djalal_start_up_mirror_0.Iref bgr_djalal_0.bgr_djalal_start_up_0.bgr_djalal_start_up_enable_0.Icpy 1.19807f
C119 beta_multiplier_0.beta_multiplier_startup_0.beta_multiplier_startup_enable_0.VS1 IOVDD 0.55248f
C120 ldo_brahim_0.ldo_brahim_pass_element2_0.VG2 ldo_brahim_0.ldo_brahim_opamp_2_stage_0/ldo_brahim_tail_0.tail 1.08097f
C121 bgr_djalal_0.bgr_djalal_resistors_0.VP1 a_16044_7614# 0.02607f
C122 bgr_djalal_0.bgr_djalal_ota_1_stage_0.bgr_djalal_ota_tail_0.tail bgr_djalal_0.bgr_djalal_ota_1_stage_0.VP 0.68324f
C123 IOVDD VDD 25.3848f
C124 a_6732_8406# a_6732_8142# 0.14652f
C125 a_4782_11344# VR 0.02091f
C126 bgr_djalal_0.bgr_djalal_ota_1_stage_0.bgr_djalal_ota_tail_0.tail bgr_djalal_0.bgr_djalal_ota_1_stage_0.bgr_djalal_ota_mirror_0.Iref 0.28393f
C127 bgr_djalal_0.bgr_djalal_ota_1_stage_0.Vout1 bgr_djalal_0.bgr_djalal_ota_1_stage_0.VN 5.6829f
C128 bgr_djalal_0.bgr_djalal_ota_1_stage_0.bgr_djalal_ota_mirror_0.Iref a_9060_8670# 0.02239f
C129 a_11388_8142# a_11388_7878# 0.14652f
C130 bgr_djalal_0.bgr_djalal_resistors_0.VP1 IOVDD 0.26334f
C131 bgr_djalal_0.bgr_djalal_ota_1_stage_0.VP Vbg 0.14761f
C132 beta_multiplier_0.beta_multiplier_startup_0.beta_multiplier_startup_enable_0.VS1 VR 3.93824f
C133 a_5838_11344# a_6102_11344# 0.2258f
C134 a_5310_7934# a_5574_7934# 0.2258f
C135 IOVDD VR 0.16143f
C136 a_5838_7934# a_6102_7934# 0.2258f
C137 ldo_brahim_0.ldo_brahim_opamp_2_stage_0/ldo_brahim_cs_0.VG Vbg 0.37837f
C138 bgr_djalal_0.bgr_djalal_ota_1_stage_0.Vout1 a_5838_11344# 0.01745f
C139 a_13716_7350# a_13716_7086# 0.14652f
C140 ldo_brahim_0.ldo_brahim_opamp_2_stage_0/ldo_brahim_cs_0.VG VFB 0.24824f
C141 a_5310_11344# IOVDD 0.01327f
C142 bgr_djalal_0.bgr_djalal_start_up_0.bgr_djalal_start_up_mirror_0.Iref IOVDD 3.50675f
C143 a_11388_7086# IOVDD 0.02599f
C144 bgr_djalal_0.bgr_djalal_resistors_0.VP1 a_9060_7878# 0.01017f
C145 a_9060_8670# a_9060_8406# 0.14652f
C146 ldo_brahim_0.I_Bias bgr_djalal_0.bgr_djalal_ota_1_stage_0.bgr_djalal_ota_tail_0.tail 3.44703f
C147 bgr_djalal_0.bgr_djalal_resistors_0.VP1 a_13716_7614# 0.01773f
C148 bgr_djalal_0.bgr_djalal_ota_1_stage_0.VN bgr_djalal_0.bgr_djalal_ota_1_stage_0.VP 6.79016f
C149 bgr_djalal_0.bgr_djalal_ota_1_stage_0.Vout1 bgr_djalal_0.bgr_djalal_start_up_0.bgr_djalal_start_up_enable_0.Icpy 0.17545f
C150 ldo_brahim_0.ldo_brahim_opamp_2_stage_0/ldo_brahim_cs_0.VG ldo_brahim_0.ldo_brahim_opamp_2_stage_0/ldo_brahim_tail_0.tail 0.40522f
C151 a_5310_11344# VR 0.02645f
C152 bgr_djalal_0.bgr_djalal_ota_1_stage_0.VN bgr_djalal_0.bgr_djalal_ota_1_stage_0.bgr_djalal_ota_mirror_0.Iref 0.29402f
C153 bgr_djalal_0.bgr_djalal_ota_1_stage_0.VP a_16044_8142# 0.02026f
C154 ldo_brahim_0.I_Bias Vbg 3.98824f
C155 ldo_brahim_0.I_Bias a_4782_7934# 0.05187f
C156 ldo_brahim_0.I_Bias a_5574_7934# 0.02835f
C157 a_11388_7878# a_11388_7614# 0.14652f
C158 ldo_brahim_0.ldo_brahim_opamp_2_stage_0/ldo_brahim_mirror_0.i_ref IOVDD 2.94818f
C159 a_6732_7350# a_6732_7086# 0.14652f
C160 a_11388_7350# a_11388_7086# 0.14652f
C161 ldo_brahim_0.ldo_brahim_pass_element2_0.VG2 a_3159_2312# 0.01032f
C162 bgr_djalal_0.bgr_djalal_resistors_0.VP1 ldo_brahim_0.ldo_brahim_opamp_2_stage_0/ldo_brahim_mirror_0.i_ref 0.04099f
C163 ldo_brahim_0.I_Bias ldo_brahim_0.ldo_brahim_opamp_2_stage_0/ldo_brahim_tail_0.tail 2.77394f
C164 a_6102_11344# IOVDD 0.02031f
C165 ldo_brahim_0.ldo_brahim_pass_element2_0.VG2 VDD 15.7891f
C166 a_3159_2312# a_3159_2048# 0.13187f
C167 ldo_brahim_0.ldo_brahim_pass_element2_0.VG2 IOVDD 25.6489f
C168 bgr_djalal_0.bgr_djalal_resistors_0.VP1 a_6732_7878# 0.01017f
C169 bgr_djalal_0.bgr_djalal_ota_1_stage_0.Vout1 IOVDD 57.6565f
C170 ldo_brahim_0.I_Bias bgr_djalal_0.bgr_djalal_ota_1_stage_0.VN 0.03233f
C171 a_11388_8670# a_11388_8406# 0.14652f
C172 bgr_djalal_0.bgr_djalal_resistors_0.VP1 a_9060_7350# 0.03407f
C173 a_16044_8670# a_16044_8406# 0.14652f
C174 beta_multiplier_0.beta_multiplier_startup_0.beta_multiplier_startup_mirror_0.VS2 ldo_brahim_0.I_Bias 0.10248f
C175 bgr_djalal_0.bgr_djalal_resistors_0.VP1 a_9060_7086# 0.06782f
C176 bgr_djalal_0.bgr_djalal_resistors_0.VP1 ldo_brahim_0.ldo_brahim_pass_element2_0.VG2 0.25705f
C177 bgr_djalal_0.bgr_djalal_ota_1_stage_0.Vout1 bgr_djalal_0.bgr_djalal_resistors_0.VP1 1.06944f
C178 a_6102_11344# VR 0.13415f
C179 a_16044_8406# a_16044_8142# 0.14652f
C180 a_9060_8142# a_9060_7878# 0.14652f
C181 bgr_djalal_0.bgr_djalal_ota_1_stage_0.bgr_djalal_ota_mirror_0.Iref a_13716_8670# 0.02077f
C182 bgr_djalal_0.bgr_djalal_ota_1_stage_0.Vout1 VR 0.02961f
C183 a_5574_11344# a_5838_11344# 0.2258f
C184 a_5046_7934# a_5310_7934# 0.2258f
C185 Vbg VFB 1.20017f
C186 bgr_djalal_0.bgr_djalal_ota_1_stage_0.Vout1 a_5310_11344# 0.01169f
C187 a_16044_7614# a_16044_7350# 0.14652f
C188 a_16044_7350# a_16044_7086# 0.14652f
C189 bgr_djalal_0.bgr_djalal_ota_1_stage_0.Vout1 bgr_djalal_0.bgr_djalal_start_up_0.bgr_djalal_start_up_mirror_0.Iref 0.01242f
R0 beta_multiplier_0.beta_multiplier_startup_0.beta_multiplier_startup_enable_0.VS1.n3 beta_multiplier_0.beta_multiplier_startup_0.beta_multiplier_startup_enable_0.VS1.n2 27.8563
R1 beta_multiplier_0.beta_multiplier_startup_0.beta_multiplier_startup_enable_0.VS1.n5 beta_multiplier_0.beta_multiplier_startup_0.beta_multiplier_startup_enable_0.VS1.n4 19.3741
R2 beta_multiplier_0.beta_multiplier_startup_0.beta_multiplier_startup_enable_0.VS1.n6 beta_multiplier_0.beta_multiplier_startup_0.beta_multiplier_startup_enable_0.VS1.n5 16.717
R3 beta_multiplier_0.beta_multiplier_startup_0.beta_multiplier_startup_enable_0.VS1.n5 beta_multiplier_0.beta_multiplier_startup_0.beta_multiplier_startup_enable_0.VS1.n3 10.245
R4 beta_multiplier_0.beta_multiplier_startup_0.beta_multiplier_startup_enable_0.VS1.n0 beta_multiplier_0.beta_multiplier_startup_0.beta_multiplier_startup_enable_0.VS1.t1 9.82416
R5 beta_multiplier_0.beta_multiplier_startup_0.beta_multiplier_startup_enable_0.VS1.n1 beta_multiplier_0.beta_multiplier_startup_0.beta_multiplier_startup_enable_0.VS1.t0 8.57981
R6 beta_multiplier_0.beta_multiplier_startup_0.beta_multiplier_startup_enable_0.VS1.n6 beta_multiplier_0.beta_multiplier_startup_0.beta_multiplier_startup_enable_0.VS1.t4 7.44475
R7 beta_multiplier_0.beta_multiplier_startup_0.beta_multiplier_startup_enable_0.VS1 beta_multiplier_0.beta_multiplier_startup_0.beta_multiplier_startup_enable_0.VS1.n7 4.6865
R8 beta_multiplier_0.beta_multiplier_startup_0.beta_multiplier_startup_enable_0.VS1 beta_multiplier_0.beta_multiplier_startup_0.beta_multiplier_startup_enable_0.VS1.n1 3.96117
R9 beta_multiplier_0.beta_multiplier_startup_0.beta_multiplier_startup_enable_0.VS1.n4 beta_multiplier_0.beta_multiplier_startup_0.beta_multiplier_startup_enable_0.VS1.t3 3.63171
R10 beta_multiplier_0.beta_multiplier_startup_0.beta_multiplier_startup_enable_0.VS1.n4 beta_multiplier_0.beta_multiplier_startup_0.beta_multiplier_startup_enable_0.VS1.t2 2.12068
R11 beta_multiplier_0.beta_multiplier_startup_0.beta_multiplier_startup_enable_0.VS1.n1 beta_multiplier_0.beta_multiplier_startup_0.beta_multiplier_startup_enable_0.VS1.n0 1.24365
R12 beta_multiplier_0.beta_multiplier_startup_0.beta_multiplier_startup_enable_0.VS1.t0 beta_multiplier_0.beta_multiplier_startup_0.beta_multiplier_startup_enable_0.VS1.n0 1.0586
R13 beta_multiplier_0.beta_multiplier_startup_0.beta_multiplier_startup_enable_0.VS1.t4 beta_multiplier_0.beta_multiplier_startup_0.beta_multiplier_startup_enable_0.VS1.n2 1.02058
R14 beta_multiplier_0.beta_multiplier_startup_0.beta_multiplier_startup_enable_0.VS1.n7 beta_multiplier_0.beta_multiplier_startup_0.beta_multiplier_startup_enable_0.VS1.n2 0.975158
R15 beta_multiplier_0.beta_multiplier_startup_0.beta_multiplier_startup_enable_0.VS1.n3 beta_multiplier_0.beta_multiplier_startup_0.beta_multiplier_startup_enable_0.VS1.t5 0.773578
R16 beta_multiplier_0.beta_multiplier_startup_0.beta_multiplier_startup_enable_0.VS1.n7 beta_multiplier_0.beta_multiplier_startup_0.beta_multiplier_startup_enable_0.VS1.n6 0.272112
R17 ldo_brahim_0.I_Bias.n0 ldo_brahim_0.I_Bias.t15 35.0664
R18 ldo_brahim_0.I_Bias.t7 ldo_brahim_0.I_Bias.n23 17.0005
R19 ldo_brahim_0.I_Bias.t7 ldo_brahim_0.I_Bias.n12 17.0005
R20 ldo_brahim_0.I_Bias.n8 ldo_brahim_0.I_Bias.n7 10.2106
R21 ldo_brahim_0.I_Bias.n7 ldo_brahim_0.I_Bias.n6 9.53648
R22 ldo_brahim_0.I_Bias.n22 ldo_brahim_0.I_Bias.t10 8.48784
R23 ldo_brahim_0.I_Bias.n9 ldo_brahim_0.I_Bias.t1 7.44301
R24 ldo_brahim_0.I_Bias.n5 ldo_brahim_0.I_Bias 7.4079
R25 ldo_brahim_0.I_Bias.n4 ldo_brahim_0.I_Bias.n3 6.69446
R26 ldo_brahim_0.I_Bias.n4 ldo_brahim_0.I_Bias.n2 6.33738
R27 ldo_brahim_0.I_Bias ldo_brahim_0.I_Bias.t18 6.24998
R28 ldo_brahim_0.I_Bias.n8 ldo_brahim_0.I_Bias.n1 5.13322
R29 ldo_brahim_0.I_Bias.n11 ldo_brahim_0.I_Bias.n10 4.97579
R30 ldo_brahim_0.I_Bias.n6 ldo_brahim_0.I_Bias.t3 4.92297
R31 ldo_brahim_0.I_Bias.n19 ldo_brahim_0.I_Bias.n18 4.38159
R32 ldo_brahim_0.I_Bias.n15 ldo_brahim_0.I_Bias.n13 4.38159
R33 ldo_brahim_0.I_Bias.n16 ldo_brahim_0.I_Bias.n15 4.38159
R34 ldo_brahim_0.I_Bias.n20 ldo_brahim_0.I_Bias.n19 4.38132
R35 ldo_brahim_0.I_Bias.t0 ldo_brahim_0.I_Bias.n0 4.28729
R36 ldo_brahim_0.I_Bias.n21 ldo_brahim_0.I_Bias.n20 3.4897
R37 ldo_brahim_0.I_Bias.n21 ldo_brahim_0.I_Bias.n13 3.48938
R38 ldo_brahim_0.I_Bias.n18 ldo_brahim_0.I_Bias.n17 3.47771
R39 ldo_brahim_0.I_Bias.n17 ldo_brahim_0.I_Bias.n16 3.47771
R40 ldo_brahim_0.I_Bias.n6 ldo_brahim_0.I_Bias.t4 2.66209
R41 ldo_brahim_0.I_Bias.n7 ldo_brahim_0.I_Bias 2.5591
R42 ldo_brahim_0.I_Bias.n10 ldo_brahim_0.I_Bias.n9 1.93847
R43 ldo_brahim_0.I_Bias.n28 ldo_brahim_0.I_Bias.n27 1.90704
R44 ldo_brahim_0.I_Bias.n26 ldo_brahim_0.I_Bias.n25 1.89257
R45 ldo_brahim_0.I_Bias ldo_brahim_0.I_Bias.n26 1.82229
R46 ldo_brahim_0.I_Bias.n27 ldo_brahim_0.I_Bias 1.50773
R47 ldo_brahim_0.I_Bias ldo_brahim_0.I_Bias.n4 1.37154
R48 ldo_brahim_0.I_Bias ldo_brahim_0.I_Bias.n5 1.36056
R49 ldo_brahim_0.I_Bias.n10 ldo_brahim_0.I_Bias.t2 0.826618
R50 ldo_brahim_0.I_Bias.n24 ldo_brahim_0.I_Bias.t7 0.635213
R51 ldo_brahim_0.I_Bias.n24 ldo_brahim_0.I_Bias.t10 0.63516
R52 ldo_brahim_0.I_Bias.n14 ldo_brahim_0.I_Bias.t8 0.592117
R53 ldo_brahim_0.I_Bias.n14 ldo_brahim_0.I_Bias.t9 0.592066
R54 ldo_brahim_0.I_Bias.n17 ldo_brahim_0.I_Bias.n14 0.431612
R55 ldo_brahim_0.I_Bias.n25 ldo_brahim_0.I_Bias.n24 0.393633
R56 ldo_brahim_0.I_Bias.n28 ldo_brahim_0.I_Bias.n0 0.289464
R57 ldo_brahim_0.I_Bias.t0 ldo_brahim_0.I_Bias.n28 0.235897
R58 ldo_brahim_0.I_Bias.n9 ldo_brahim_0.I_Bias.n8 0.196034
R59 ldo_brahim_0.I_Bias.n20 ldo_brahim_0.I_Bias.t6 0.132966
R60 ldo_brahim_0.I_Bias.n18 ldo_brahim_0.I_Bias.t5 0.13273
R61 ldo_brahim_0.I_Bias.n19 ldo_brahim_0.I_Bias.t13 0.13273
R62 ldo_brahim_0.I_Bias.n16 ldo_brahim_0.I_Bias.t11 0.13273
R63 ldo_brahim_0.I_Bias.n15 ldo_brahim_0.I_Bias.t14 0.13273
R64 ldo_brahim_0.I_Bias.n13 ldo_brahim_0.I_Bias.t12 0.13273
R65 ldo_brahim_0.I_Bias.n27 ldo_brahim_0.I_Bias 0.0625
R66 ldo_brahim_0.I_Bias.n23 ldo_brahim_0.I_Bias.n21 0.0622808
R67 ldo_brahim_0.I_Bias.n11 ldo_brahim_0.I_Bias 0.0621
R68 ldo_brahim_0.I_Bias.n5 ldo_brahim_0.I_Bias 0.0511
R69 ldo_brahim_0.I_Bias ldo_brahim_0.I_Bias.n11 0.0445
R70 ldo_brahim_0.I_Bias.n26 ldo_brahim_0.I_Bias 0.0273889
R71 ldo_brahim_0.I_Bias.n22 ldo_brahim_0.I_Bias.n12 0.027329
R72 ldo_brahim_0.I_Bias.n23 ldo_brahim_0.I_Bias.n22 0.027329
R73 ldo_brahim_0.I_Bias.n5 ldo_brahim_0.I_Bias 0.0236579
R74 ldo_brahim_0.I_Bias.n25 ldo_brahim_0.I_Bias.n12 0.0125548
R75 ldo_brahim_0.I_Bias.t16 ldo_brahim_0.I_Bias.n2 0.00405711
R76 ldo_brahim_0.I_Bias.n3 ldo_brahim_0.I_Bias.t16 0.00261825
R77 ldo_brahim_0.I_Bias.t17 ldo_brahim_0.I_Bias.n2 0.00194243
R78 ldo_brahim_0.I_Bias.n3 ldo_brahim_0.I_Bias.t17 0.00138153
R79 ldo_brahim_0.I_Bias.t3 ldo_brahim_0.I_Bias.n1 0.001
R80 ldo_brahim_0.I_Bias.n1 ldo_brahim_0.I_Bias.t1 0.001
R81 VR.n16 VR.n15 32.2794
R82 VR.n15 VR.t0 29.2591
R83 VR.n18 VR.n14 8.2704
R84 VR.n11 VR.t16 7.48373
R85 VR.t16 VR.n0 7.48373
R86 VR VR.n12 5.1279
R87 VR.n18 VR.n17 5.03273
R88 VR.n13 VR.t15 4.97048
R89 VR.n17 VR.n16 4.33478
R90 VR.n13 VR.t14 3.34007
R91 VR.n16 VR.t12 2.60954
R92 VR.n10 VR.n9 2.28456
R93 VR.n5 VR.n4 2.28456
R94 VR.n9 VR.n8 2.27289
R95 VR.n7 VR.n5 2.27289
R96 VR.n14 VR.n13 1.79335
R97 VR.n14 VR.t11 1.442
R98 VR.n8 VR.n7 1.42363
R99 VR.n3 VR.t5 0.592117
R100 VR.n1 VR.t2 0.592117
R101 VR.n2 VR.t3 0.592117
R102 VR.n6 VR.t6 0.592117
R103 VR.n1 VR.t9 0.592066
R104 VR.n3 VR.t10 0.592066
R105 VR.n2 VR.t1 0.592066
R106 VR.n6 VR.t7 0.592066
R107 VR.n8 VR.n2 0.432199
R108 VR.n7 VR.n6 0.432199
R109 VR.n10 VR.n1 0.431612
R110 VR.n4 VR.n3 0.431612
R111 VR VR.n18 0.419398
R112 VR.n4 VR.n0 0.343906
R113 VR.n11 VR.n10 0.323281
R114 VR.n15 VR 0.143121
R115 VR.n17 VR.t13 0.136934
R116 VR.n9 VR.t4 0.13273
R117 VR.n5 VR.t8 0.13273
R118 VR.n12 VR.n11 0.0803647
R119 VR.n12 VR.n0 0.0599943
R120 VSS.n2931 VSS.n2930 37053.4
R121 VSS.n2929 VSS.n2928 31487.1
R122 VSS.n2930 VSS.n2929 28420.5
R123 VSS.n2930 VSS.n67 15340.8
R124 VSS.n2928 VSS.n69 9216.37
R125 VSS.n2929 VSS.n68 5210.44
R126 VSS.n1118 VSS.n67 1190.69
R127 VSS.n867 VSS.t0 452.055
R128 VSS.t128 VSS.n867 384.411
R129 VSS.n2928 VSS.n2927 205.571
R130 VSS.n901 VSS.t8 178.939
R131 VSS.t185 VSS.n1857 176.154
R132 VSS.t4 VSS.n1117 135.44
R133 VSS.t4 VSS.n651 135.44
R134 VSS.n1118 VSS.n650 110.008
R135 VSS.n2744 VSS.n2520 103.206
R136 VSS.n2751 VSS.n651 99.549
R137 VSS.n1792 VSS.n1691 95.8117
R138 VSS.n2875 VSS.n2874 90.1288
R139 VSS.n2920 VSS.n2919 72.7025
R140 VSS.t187 VSS.n1789 71.605
R141 VSS.n1791 VSS.t188 70.478
R142 VSS.t184 VSS.n1788 67.7285
R143 VSS.t186 VSS.n1787 63.8371
R144 VSS.n2751 VSS.n2749 59.2239
R145 VSS.t64 VSS.n2748 50.3414
R146 VSS.t4 VSS.n1118 38.5368
R147 VSS.n2747 VSS.n2746 35.9731
R148 VSS.n899 VSS.n586 34.2471
R149 VSS.n898 VSS.n585 34.2471
R150 VSS.n897 VSS.n584 34.2471
R151 VSS.n896 VSS.n583 34.2471
R152 VSS.n895 VSS.n582 34.2471
R153 VSS.n894 VSS.n581 34.2471
R154 VSS.n893 VSS.n580 34.2471
R155 VSS.n892 VSS.n579 34.2471
R156 VSS.n891 VSS.n578 34.2471
R157 VSS.n890 VSS.n577 34.2471
R158 VSS.n889 VSS.n576 34.2471
R159 VSS.n888 VSS.n575 34.2471
R160 VSS.n887 VSS.n574 34.2471
R161 VSS.n872 VSS.n572 34.2471
R162 VSS.n870 VSS.n570 34.2471
R163 VSS.n865 VSS.n566 34.2471
R164 VSS.n863 VSS.n564 34.2471
R165 VSS.n861 VSS.n562 34.2471
R166 VSS.n859 VSS.n560 34.2471
R167 VSS.n857 VSS.n558 34.2471
R168 VSS.n856 VSS.n556 34.2471
R169 VSS.n851 VSS.n552 32.0347
R170 VSS.n849 VSS.n550 32.0347
R171 VSS.n847 VSS.n548 32.0347
R172 VSS.n845 VSS.n546 32.0347
R173 VSS.n843 VSS.n544 32.0347
R174 VSS.n841 VSS.n542 32.0347
R175 VSS.n839 VSS.n540 32.0347
R176 VSS.n831 VSS.n537 32.0347
R177 VSS.n828 VSS.n536 32.0347
R178 VSS.n825 VSS.n535 32.0347
R179 VSS.n822 VSS.n534 32.0347
R180 VSS.n819 VSS.n533 32.0347
R181 VSS.n816 VSS.n532 32.0347
R182 VSS.n813 VSS.n531 32.0347
R183 VSS.n810 VSS.n530 32.0347
R184 VSS.n807 VSS.n529 32.0347
R185 VSS.n804 VSS.n528 32.0347
R186 VSS.n801 VSS.n527 32.0347
R187 VSS.n798 VSS.n526 32.0347
R188 VSS.n795 VSS.n525 32.0347
R189 VSS.n792 VSS.n524 32.0347
R190 VSS.n789 VSS.n523 32.0347
R191 VSS.n786 VSS.n522 32.0347
R192 VSS.n783 VSS.n521 32.0347
R193 VSS.n776 VSS.n519 32.0347
R194 VSS.n773 VSS.n518 32.0347
R195 VSS.n770 VSS.n517 32.0347
R196 VSS.n767 VSS.n516 32.0347
R197 VSS.n764 VSS.n515 32.0347
R198 VSS.n761 VSS.n514 32.0347
R199 VSS.n758 VSS.n513 32.0347
R200 VSS.n755 VSS.n512 32.0347
R201 VSS.n752 VSS.n511 32.0347
R202 VSS.n749 VSS.n510 32.0347
R203 VSS.n746 VSS.n509 32.0347
R204 VSS.n743 VSS.n508 32.0347
R205 VSS.n740 VSS.n507 32.0347
R206 VSS.n737 VSS.n506 32.0347
R207 VSS.n726 VSS.n505 32.0347
R208 VSS.t64 VSS.n37 30.1025
R209 VSS.n902 VSS.n901 29.9663
R210 VSS.n867 VSS.n555 27.3978
R211 VSS.t1 VSS.n503 25.6278
R212 VSS.n1676 VSS.n502 25.6278
R213 VSS.n483 VSS.n462 24.6523
R214 VSS.n484 VSS.n461 24.6523
R215 VSS.n485 VSS.n460 24.6523
R216 VSS.n486 VSS.n459 24.6523
R217 VSS.n488 VSS.n458 24.6523
R218 VSS.n489 VSS.n457 24.6523
R219 VSS.n491 VSS.n456 24.6523
R220 VSS.n902 VSS.n586 23.9731
R221 VSS.n899 VSS.n585 23.9731
R222 VSS.n898 VSS.n584 23.9731
R223 VSS.n897 VSS.n583 23.9731
R224 VSS.n896 VSS.n582 23.9731
R225 VSS.n895 VSS.n581 23.9731
R226 VSS.n894 VSS.n580 23.9731
R227 VSS.n893 VSS.n579 23.9731
R228 VSS.n892 VSS.n578 23.9731
R229 VSS.n891 VSS.n577 23.9731
R230 VSS.n890 VSS.n576 23.9731
R231 VSS.n889 VSS.n575 23.9731
R232 VSS.n888 VSS.n574 23.9731
R233 VSS.n887 VSS.n572 23.9731
R234 VSS.n872 VSS.n570 23.9731
R235 VSS.n870 VSS.n568 23.9731
R236 VSS.t128 VSS.n568 23.9731
R237 VSS.n868 VSS.n566 23.9731
R238 VSS.n865 VSS.n564 23.9731
R239 VSS.n863 VSS.n562 23.9731
R240 VSS.n861 VSS.n560 23.9731
R241 VSS.n859 VSS.n558 23.9731
R242 VSS.n857 VSS.n556 23.9731
R243 VSS.n856 VSS.n555 23.9731
R244 VSS.n853 VSS.n552 22.4244
R245 VSS.n851 VSS.n550 22.4244
R246 VSS.n849 VSS.n548 22.4244
R247 VSS.n847 VSS.n546 22.4244
R248 VSS.n845 VSS.n544 22.4244
R249 VSS.n843 VSS.n542 22.4244
R250 VSS.n841 VSS.n540 22.4244
R251 VSS.n839 VSS.n538 22.4244
R252 VSS.n834 VSS.n537 22.4244
R253 VSS.n831 VSS.n536 22.4244
R254 VSS.n828 VSS.n535 22.4244
R255 VSS.n825 VSS.n534 22.4244
R256 VSS.n822 VSS.n533 22.4244
R257 VSS.n819 VSS.n532 22.4244
R258 VSS.n816 VSS.n531 22.4244
R259 VSS.n813 VSS.n530 22.4244
R260 VSS.n810 VSS.n529 22.4244
R261 VSS.n807 VSS.n528 22.4244
R262 VSS.n804 VSS.n527 22.4244
R263 VSS.n801 VSS.n526 22.4244
R264 VSS.n798 VSS.n525 22.4244
R265 VSS.n795 VSS.n524 22.4244
R266 VSS.n792 VSS.n523 22.4244
R267 VSS.n789 VSS.n522 22.4244
R268 VSS.n786 VSS.n521 22.4244
R269 VSS.n783 VSS.n520 22.4244
R270 VSS.t14 VSS.n520 22.4244
R271 VSS.n779 VSS.n519 22.4244
R272 VSS.n776 VSS.n518 22.4244
R273 VSS.n773 VSS.n517 22.4244
R274 VSS.n770 VSS.n516 22.4244
R275 VSS.n767 VSS.n515 22.4244
R276 VSS.n764 VSS.n514 22.4244
R277 VSS.n761 VSS.n513 22.4244
R278 VSS.n758 VSS.n512 22.4244
R279 VSS.n755 VSS.n511 22.4244
R280 VSS.n752 VSS.n510 22.4244
R281 VSS.n749 VSS.n509 22.4244
R282 VSS.n746 VSS.n508 22.4244
R283 VSS.n743 VSS.n507 22.4244
R284 VSS.n740 VSS.n506 22.4244
R285 VSS.n737 VSS.n505 22.4244
R286 VSS.n726 VSS.n503 22.4244
R287 VSS.n2330 VSS.n1678 22.313
R288 VSS.n482 VSS.t19 21.3097
R289 VSS.n2749 VSS.t64 21.2978
R290 VSS.n316 VSS.t28 20.0562
R291 VSS.t0 VSS.n834 19.221
R292 VSS.n2746 VSS.n647 18.8131
R293 VSS.n2927 VSS.n71 18.3849
R294 VSS.n2925 VSS.n2924 18.3849
R295 VSS.n256 VSS.n181 18.3849
R296 VSS.n257 VSS.n180 18.3849
R297 VSS.n261 VSS.n179 18.3849
R298 VSS.n268 VSS.n175 18.3849
R299 VSS.n272 VSS.n171 18.3849
R300 VSS.n273 VSS.n168 18.3849
R301 VSS.n280 VSS.n167 18.3849
R302 VSS.n281 VSS.n164 18.3849
R303 VSS.n287 VSS.n163 18.3849
R304 VSS.n288 VSS.n160 18.3849
R305 VSS.t32 VSS.n159 18.3849
R306 VSS.n290 VSS.n156 18.3849
R307 VSS.n294 VSS.n152 18.3849
R308 VSS.n302 VSS.n151 18.3849
R309 VSS.n303 VSS.n148 18.3849
R310 VSS.n307 VSS.n147 18.3849
R311 VSS.n308 VSS.n144 18.3849
R312 VSS.n309 VSS.n143 18.3849
R313 VSS.n310 VSS.n140 18.3849
R314 VSS.n311 VSS.n139 18.3849
R315 VSS.n312 VSS.n136 18.3849
R316 VSS.n313 VSS.n135 18.3849
R317 VSS.n314 VSS.n132 18.3849
R318 VSS.n315 VSS.n131 18.3849
R319 VSS.n316 VSS.n127 18.3849
R320 VSS.n317 VSS.n124 18.3849
R321 VSS.n318 VSS.n123 18.3849
R322 VSS.n320 VSS.n120 18.3849
R323 VSS.n321 VSS.n119 18.3849
R324 VSS.n322 VSS.n116 18.3849
R325 VSS.n323 VSS.n115 18.3849
R326 VSS.n324 VSS.n112 18.3849
R327 VSS.n325 VSS.n111 18.3849
R328 VSS.n327 VSS.n108 18.3849
R329 VSS.n328 VSS.n107 18.3849
R330 VSS.n332 VSS.n104 18.3849
R331 VSS.n336 VSS.n100 18.3849
R332 VSS.t30 VSS.n99 18.3849
R333 VSS.n339 VSS.n96 18.3849
R334 VSS.n340 VSS.n95 18.3849
R335 VSS.n344 VSS.n92 18.3849
R336 VSS.n345 VSS.n91 18.3849
R337 VSS.n349 VSS.n88 18.3849
R338 VSS.n350 VSS.n87 18.3849
R339 VSS.n354 VSS.n83 18.3849
R340 VSS.n358 VSS.n79 18.3849
R341 VSS.n363 VSS.n76 18.3849
R342 VSS.n364 VSS.n75 18.3849
R343 VSS.n367 VSS.n74 18.3849
R344 VSS.n2921 VSS.n2920 18.3849
R345 VSS.n2916 VSS.n449 17.9671
R346 VSS.n2915 VSS.n470 17.9671
R347 VSS.n476 VSS.n469 17.9671
R348 VSS.n477 VSS.n467 17.9671
R349 VSS.n478 VSS.n466 17.9671
R350 VSS.n479 VSS.n465 17.9671
R351 VSS.n480 VSS.n464 17.9671
R352 VSS.n694 VSS.n502 17.6193
R353 VSS.n1788 VSS.t186 17.3111
R354 VSS.n2757 VSS.n2422 17.083
R355 VSS.t148 VSS.n2321 17.0005
R356 VSS.n2316 VSS.t113 17.0005
R357 VSS.n2318 VSS.t114 17.0005
R358 VSS.n2323 VSS.t149 17.0005
R359 VSS.n2240 VSS.t38 17.0005
R360 VSS.n2241 VSS.t39 17.0005
R361 VSS.t40 VSS.n2238 17.0005
R362 VSS.n2243 VSS.t36 17.0005
R363 VSS.n2171 VSS.t142 17.0005
R364 VSS.t61 VSS.n2176 17.0005
R365 VSS.n2173 VSS.t143 17.0005
R366 VSS.n2178 VSS.t62 17.0005
R367 VSS.n2758 VSS.t116 17.0005
R368 VSS.n2756 VSS.t116 17.0005
R369 VSS.n2437 VSS.t116 17.0005
R370 VSS.n2436 VSS.t116 17.0005
R371 VSS.n2435 VSS.t116 17.0005
R372 VSS.n2434 VSS.t116 17.0005
R373 VSS.n2433 VSS.t116 17.0005
R374 VSS.n2432 VSS.t116 17.0005
R375 VSS.n2431 VSS.t116 17.0005
R376 VSS.n2430 VSS.t116 17.0005
R377 VSS.n2429 VSS.t116 17.0005
R378 VSS.n2758 VSS.n2757 17.0005
R379 VSS.n2757 VSS.n2756 17.0005
R380 VSS.n2757 VSS.n2437 17.0005
R381 VSS.n2757 VSS.n2436 17.0005
R382 VSS.n2757 VSS.n2435 17.0005
R383 VSS.n2757 VSS.n2434 17.0005
R384 VSS.n2757 VSS.n2433 17.0005
R385 VSS.n2757 VSS.n2432 17.0005
R386 VSS.n2757 VSS.n2431 17.0005
R387 VSS.n2757 VSS.n2430 17.0005
R388 VSS.n2757 VSS.n2429 17.0005
R389 VSS.n2757 VSS.n2425 17.0005
R390 VSS.t106 VSS.n2836 17.0005
R391 VSS.t106 VSS.n2834 17.0005
R392 VSS.t106 VSS.n2832 17.0005
R393 VSS.t106 VSS.n2830 17.0005
R394 VSS.t106 VSS.n2828 17.0005
R395 VSS.t106 VSS.n2826 17.0005
R396 VSS.t106 VSS.n2824 17.0005
R397 VSS.t106 VSS.n2822 17.0005
R398 VSS.t106 VSS.n2820 17.0005
R399 VSS.t106 VSS.n2818 17.0005
R400 VSS.t106 VSS.n2816 17.0005
R401 VSS.t106 VSS.n2814 17.0005
R402 VSS.t106 VSS.n2810 17.0005
R403 VSS.t106 VSS.n2808 17.0005
R404 VSS.t106 VSS.n2806 17.0005
R405 VSS.t106 VSS.n2804 17.0005
R406 VSS.t106 VSS.n2802 17.0005
R407 VSS.t106 VSS.n2800 17.0005
R408 VSS.t106 VSS.n2798 17.0005
R409 VSS.t106 VSS.n2796 17.0005
R410 VSS.t106 VSS.n2794 17.0005
R411 VSS.t106 VSS.n2792 17.0005
R412 VSS.t106 VSS.n2790 17.0005
R413 VSS.t106 VSS.n2788 17.0005
R414 VSS.t106 VSS.n2786 17.0005
R415 VSS.t106 VSS.n2784 17.0005
R416 VSS.n2837 VSS.t106 17.0005
R417 VSS.t98 VSS.n2636 17.0005
R418 VSS.n2665 VSS.t99 17.0005
R419 VSS.n2670 VSS.t66 17.0005
R420 VSS.t66 VSS.n2669 17.0005
R421 VSS.n2605 VSS.t136 17.0005
R422 VSS.t135 VSS.n2576 17.0005
R423 VSS.n2610 VSS.t119 17.0005
R424 VSS.t119 VSS.n2609 17.0005
R425 VSS.n218 VSS.n214 17.0005
R426 VSS.n218 VSS.n213 17.0005
R427 VSS.n218 VSS.n215 17.0005
R428 VSS.n218 VSS.n212 17.0005
R429 VSS.n219 VSS.n218 17.0005
R430 VSS.n218 VSS.n211 17.0005
R431 VSS.n218 VSS.n216 17.0005
R432 VSS.n218 VSS.n217 17.0005
R433 VSS.n1351 VSS.t11 17.0005
R434 VSS.t24 VSS.n1348 17.0005
R435 VSS.t24 VSS.n1346 17.0005
R436 VSS.t24 VSS.n1343 17.0005
R437 VSS.t157 VSS.n1408 17.0005
R438 VSS.t157 VSS.n1409 17.0005
R439 VSS.t157 VSS.n1413 17.0005
R440 VSS.t157 VSS.n1414 17.0005
R441 VSS.t157 VSS.n1418 17.0005
R442 VSS.t157 VSS.n1419 17.0005
R443 VSS.t157 VSS.n1423 17.0005
R444 VSS.t157 VSS.n1424 17.0005
R445 VSS.t157 VSS.n1430 17.0005
R446 VSS.t157 VSS.n1434 17.0005
R447 VSS.t157 VSS.n1435 17.0005
R448 VSS.t157 VSS.n1439 17.0005
R449 VSS.t157 VSS.n1440 17.0005
R450 VSS.t157 VSS.n1444 17.0005
R451 VSS.t157 VSS.n1445 17.0005
R452 VSS.t157 VSS.n1449 17.0005
R453 VSS.t157 VSS.n1450 17.0005
R454 VSS.n1457 VSS.t157 17.0005
R455 VSS.t104 VSS.n1571 17.0005
R456 VSS.t104 VSS.n1286 17.0005
R457 VSS.t51 VSS.n1232 17.0005
R458 VSS.n1233 VSS.t51 17.0005
R459 VSS.t51 VSS.n1230 17.0005
R460 VSS.t152 VSS.n1222 17.0005
R461 VSS.n1223 VSS.t152 17.0005
R462 VSS.t152 VSS.n1220 17.0005
R463 VSS.t129 VSS.n923 17.0005
R464 VSS.n924 VSS.t129 17.0005
R465 VSS.t129 VSS.n920 17.0005
R466 VSS.t145 VSS.n906 17.0005
R467 VSS.n909 VSS.t145 17.0005
R468 VSS.t145 VSS.n908 17.0005
R469 VSS.n734 VSS.t18 17.0005
R470 VSS.n732 VSS.t15 17.0005
R471 VSS.n731 VSS.t13 17.0005
R472 VSS.n729 VSS.t16 17.0005
R473 VSS.n724 VSS.n499 17.0005
R474 VSS.n502 VSS.n499 17.0005
R475 VSS.n735 VSS.n499 17.0005
R476 VSS.n503 VSS.n499 17.0005
R477 VSS.n738 VSS.n499 17.0005
R478 VSS.n505 VSS.n499 17.0005
R479 VSS.n741 VSS.n499 17.0005
R480 VSS.n506 VSS.n499 17.0005
R481 VSS.n744 VSS.n499 17.0005
R482 VSS.n507 VSS.n499 17.0005
R483 VSS.n747 VSS.n499 17.0005
R484 VSS.n508 VSS.n499 17.0005
R485 VSS.n750 VSS.n499 17.0005
R486 VSS.n509 VSS.n499 17.0005
R487 VSS.n753 VSS.n499 17.0005
R488 VSS.n510 VSS.n499 17.0005
R489 VSS.n756 VSS.n499 17.0005
R490 VSS.n511 VSS.n499 17.0005
R491 VSS.n759 VSS.n499 17.0005
R492 VSS.n512 VSS.n499 17.0005
R493 VSS.n762 VSS.n499 17.0005
R494 VSS.n513 VSS.n499 17.0005
R495 VSS.n765 VSS.n499 17.0005
R496 VSS.n514 VSS.n499 17.0005
R497 VSS.n768 VSS.n499 17.0005
R498 VSS.n515 VSS.n499 17.0005
R499 VSS.n771 VSS.n499 17.0005
R500 VSS.n516 VSS.n499 17.0005
R501 VSS.n774 VSS.n499 17.0005
R502 VSS.n517 VSS.n499 17.0005
R503 VSS.n777 VSS.n499 17.0005
R504 VSS.n518 VSS.n499 17.0005
R505 VSS.n780 VSS.n499 17.0005
R506 VSS.n519 VSS.n499 17.0005
R507 VSS.n784 VSS.n499 17.0005
R508 VSS.n520 VSS.n499 17.0005
R509 VSS.n787 VSS.n499 17.0005
R510 VSS.n521 VSS.n499 17.0005
R511 VSS.n790 VSS.n499 17.0005
R512 VSS.n522 VSS.n499 17.0005
R513 VSS.n793 VSS.n499 17.0005
R514 VSS.n523 VSS.n499 17.0005
R515 VSS.n796 VSS.n499 17.0005
R516 VSS.n524 VSS.n499 17.0005
R517 VSS.n799 VSS.n499 17.0005
R518 VSS.n525 VSS.n499 17.0005
R519 VSS.n802 VSS.n499 17.0005
R520 VSS.n526 VSS.n499 17.0005
R521 VSS.n805 VSS.n499 17.0005
R522 VSS.n527 VSS.n499 17.0005
R523 VSS.n808 VSS.n499 17.0005
R524 VSS.n528 VSS.n499 17.0005
R525 VSS.n811 VSS.n499 17.0005
R526 VSS.n529 VSS.n499 17.0005
R527 VSS.n814 VSS.n499 17.0005
R528 VSS.n530 VSS.n499 17.0005
R529 VSS.n817 VSS.n499 17.0005
R530 VSS.n531 VSS.n499 17.0005
R531 VSS.n820 VSS.n499 17.0005
R532 VSS.n532 VSS.n499 17.0005
R533 VSS.n823 VSS.n499 17.0005
R534 VSS.n533 VSS.n499 17.0005
R535 VSS.n826 VSS.n499 17.0005
R536 VSS.n534 VSS.n499 17.0005
R537 VSS.n829 VSS.n499 17.0005
R538 VSS.n535 VSS.n499 17.0005
R539 VSS.n832 VSS.n499 17.0005
R540 VSS.n536 VSS.n499 17.0005
R541 VSS.n835 VSS.n499 17.0005
R542 VSS.n537 VSS.n499 17.0005
R543 VSS.n539 VSS.n499 17.0005
R544 VSS.n538 VSS.n499 17.0005
R545 VSS.n541 VSS.n499 17.0005
R546 VSS.n540 VSS.n499 17.0005
R547 VSS.n543 VSS.n499 17.0005
R548 VSS.n542 VSS.n499 17.0005
R549 VSS.n545 VSS.n499 17.0005
R550 VSS.n544 VSS.n499 17.0005
R551 VSS.n547 VSS.n499 17.0005
R552 VSS.n546 VSS.n499 17.0005
R553 VSS.n549 VSS.n499 17.0005
R554 VSS.n548 VSS.n499 17.0005
R555 VSS.n551 VSS.n499 17.0005
R556 VSS.n550 VSS.n499 17.0005
R557 VSS.n553 VSS.n499 17.0005
R558 VSS.n552 VSS.n499 17.0005
R559 VSS.n2907 VSS.n553 17.0005
R560 VSS.n2907 VSS.n552 17.0005
R561 VSS.n2907 VSS.n551 17.0005
R562 VSS.n2907 VSS.n550 17.0005
R563 VSS.n2907 VSS.n549 17.0005
R564 VSS.n2907 VSS.n548 17.0005
R565 VSS.n2907 VSS.n547 17.0005
R566 VSS.n2907 VSS.n546 17.0005
R567 VSS.n2907 VSS.n545 17.0005
R568 VSS.n2907 VSS.n544 17.0005
R569 VSS.n2907 VSS.n543 17.0005
R570 VSS.n2907 VSS.n542 17.0005
R571 VSS.n2907 VSS.n541 17.0005
R572 VSS.n2907 VSS.n540 17.0005
R573 VSS.n2907 VSS.n539 17.0005
R574 VSS.n2907 VSS.n538 17.0005
R575 VSS.n2907 VSS.n537 17.0005
R576 VSS.n2907 VSS.n536 17.0005
R577 VSS.n2907 VSS.n535 17.0005
R578 VSS.n2907 VSS.n534 17.0005
R579 VSS.n2907 VSS.n533 17.0005
R580 VSS.n2907 VSS.n532 17.0005
R581 VSS.n2907 VSS.n531 17.0005
R582 VSS.n2907 VSS.n530 17.0005
R583 VSS.n2907 VSS.n529 17.0005
R584 VSS.n2907 VSS.n528 17.0005
R585 VSS.n2907 VSS.n527 17.0005
R586 VSS.n2907 VSS.n526 17.0005
R587 VSS.n2907 VSS.n525 17.0005
R588 VSS.n2907 VSS.n524 17.0005
R589 VSS.n2907 VSS.n523 17.0005
R590 VSS.n2907 VSS.n522 17.0005
R591 VSS.n2907 VSS.n521 17.0005
R592 VSS.n2907 VSS.n520 17.0005
R593 VSS.n2907 VSS.n519 17.0005
R594 VSS.n2907 VSS.n518 17.0005
R595 VSS.n2907 VSS.n517 17.0005
R596 VSS.n2907 VSS.n516 17.0005
R597 VSS.n2907 VSS.n515 17.0005
R598 VSS.n2907 VSS.n514 17.0005
R599 VSS.n2907 VSS.n513 17.0005
R600 VSS.n2907 VSS.n512 17.0005
R601 VSS.n2907 VSS.n511 17.0005
R602 VSS.n2907 VSS.n510 17.0005
R603 VSS.n2907 VSS.n509 17.0005
R604 VSS.n2907 VSS.n508 17.0005
R605 VSS.n2907 VSS.n507 17.0005
R606 VSS.n2907 VSS.n506 17.0005
R607 VSS.n2907 VSS.n505 17.0005
R608 VSS.n2907 VSS.n503 17.0005
R609 VSS.n2907 VSS.n502 17.0005
R610 VSS.n726 VSS.n474 17.0005
R611 VSS.n737 VSS.n474 17.0005
R612 VSS.n740 VSS.n474 17.0005
R613 VSS.n743 VSS.n474 17.0005
R614 VSS.n746 VSS.n474 17.0005
R615 VSS.n749 VSS.n474 17.0005
R616 VSS.n752 VSS.n474 17.0005
R617 VSS.n755 VSS.n474 17.0005
R618 VSS.n758 VSS.n474 17.0005
R619 VSS.n761 VSS.n474 17.0005
R620 VSS.n764 VSS.n474 17.0005
R621 VSS.n767 VSS.n474 17.0005
R622 VSS.n770 VSS.n474 17.0005
R623 VSS.n773 VSS.n474 17.0005
R624 VSS.n776 VSS.n474 17.0005
R625 VSS.n779 VSS.n474 17.0005
R626 VSS.n783 VSS.n474 17.0005
R627 VSS.n786 VSS.n474 17.0005
R628 VSS.n789 VSS.n474 17.0005
R629 VSS.n792 VSS.n474 17.0005
R630 VSS.n795 VSS.n474 17.0005
R631 VSS.n798 VSS.n474 17.0005
R632 VSS.n801 VSS.n474 17.0005
R633 VSS.n804 VSS.n474 17.0005
R634 VSS.n807 VSS.n474 17.0005
R635 VSS.n810 VSS.n474 17.0005
R636 VSS.n813 VSS.n474 17.0005
R637 VSS.n816 VSS.n474 17.0005
R638 VSS.n819 VSS.n474 17.0005
R639 VSS.n822 VSS.n474 17.0005
R640 VSS.n825 VSS.n474 17.0005
R641 VSS.n828 VSS.n474 17.0005
R642 VSS.n831 VSS.n474 17.0005
R643 VSS.n834 VSS.n474 17.0005
R644 VSS.n839 VSS.n474 17.0005
R645 VSS.n841 VSS.n474 17.0005
R646 VSS.n843 VSS.n474 17.0005
R647 VSS.n845 VSS.n474 17.0005
R648 VSS.n847 VSS.n474 17.0005
R649 VSS.n849 VSS.n474 17.0005
R650 VSS.n851 VSS.n474 17.0005
R651 VSS.n853 VSS.n474 17.0005
R652 VSS.n1675 VSS.n854 17.0005
R653 VSS.n1675 VSS.n853 17.0005
R654 VSS.n1675 VSS.n852 17.0005
R655 VSS.n1675 VSS.n851 17.0005
R656 VSS.n1675 VSS.n850 17.0005
R657 VSS.n1675 VSS.n849 17.0005
R658 VSS.n1675 VSS.n848 17.0005
R659 VSS.n1675 VSS.n847 17.0005
R660 VSS.n1675 VSS.n846 17.0005
R661 VSS.n1675 VSS.n845 17.0005
R662 VSS.n1675 VSS.n844 17.0005
R663 VSS.n1675 VSS.n843 17.0005
R664 VSS.n1675 VSS.n842 17.0005
R665 VSS.n1675 VSS.n841 17.0005
R666 VSS.n1675 VSS.n840 17.0005
R667 VSS.n1675 VSS.n839 17.0005
R668 VSS.n1675 VSS.n838 17.0005
R669 VSS.n1675 VSS.n834 17.0005
R670 VSS.n1675 VSS.n833 17.0005
R671 VSS.n1675 VSS.n831 17.0005
R672 VSS.n1675 VSS.n830 17.0005
R673 VSS.n1675 VSS.n828 17.0005
R674 VSS.n1675 VSS.n827 17.0005
R675 VSS.n1675 VSS.n825 17.0005
R676 VSS.n1675 VSS.n824 17.0005
R677 VSS.n1675 VSS.n822 17.0005
R678 VSS.n1675 VSS.n821 17.0005
R679 VSS.n1675 VSS.n819 17.0005
R680 VSS.n1675 VSS.n818 17.0005
R681 VSS.n1675 VSS.n816 17.0005
R682 VSS.n1675 VSS.n815 17.0005
R683 VSS.n1675 VSS.n813 17.0005
R684 VSS.n1675 VSS.n812 17.0005
R685 VSS.n1675 VSS.n810 17.0005
R686 VSS.n1675 VSS.n809 17.0005
R687 VSS.n1675 VSS.n807 17.0005
R688 VSS.n1675 VSS.n806 17.0005
R689 VSS.n1675 VSS.n804 17.0005
R690 VSS.n1675 VSS.n803 17.0005
R691 VSS.n1675 VSS.n801 17.0005
R692 VSS.n1675 VSS.n800 17.0005
R693 VSS.n1675 VSS.n798 17.0005
R694 VSS.n1675 VSS.n797 17.0005
R695 VSS.n1675 VSS.n795 17.0005
R696 VSS.n1675 VSS.n794 17.0005
R697 VSS.n1675 VSS.n792 17.0005
R698 VSS.n1675 VSS.n791 17.0005
R699 VSS.n1675 VSS.n789 17.0005
R700 VSS.n1675 VSS.n788 17.0005
R701 VSS.n1675 VSS.n786 17.0005
R702 VSS.n1675 VSS.n785 17.0005
R703 VSS.n1675 VSS.n783 17.0005
R704 VSS.n1675 VSS.n782 17.0005
R705 VSS.n1675 VSS.n779 17.0005
R706 VSS.n1675 VSS.n778 17.0005
R707 VSS.n1675 VSS.n776 17.0005
R708 VSS.n1675 VSS.n775 17.0005
R709 VSS.n1675 VSS.n773 17.0005
R710 VSS.n1675 VSS.n772 17.0005
R711 VSS.n1675 VSS.n770 17.0005
R712 VSS.n1675 VSS.n769 17.0005
R713 VSS.n1675 VSS.n767 17.0005
R714 VSS.n1675 VSS.n766 17.0005
R715 VSS.n1675 VSS.n764 17.0005
R716 VSS.n1675 VSS.n763 17.0005
R717 VSS.n1675 VSS.n761 17.0005
R718 VSS.n1675 VSS.n760 17.0005
R719 VSS.n1675 VSS.n758 17.0005
R720 VSS.n1675 VSS.n757 17.0005
R721 VSS.n1675 VSS.n755 17.0005
R722 VSS.n1675 VSS.n754 17.0005
R723 VSS.n1675 VSS.n752 17.0005
R724 VSS.n1675 VSS.n751 17.0005
R725 VSS.n1675 VSS.n749 17.0005
R726 VSS.n1675 VSS.n748 17.0005
R727 VSS.n1675 VSS.n746 17.0005
R728 VSS.n1675 VSS.n745 17.0005
R729 VSS.n1675 VSS.n743 17.0005
R730 VSS.n1675 VSS.n742 17.0005
R731 VSS.n1675 VSS.n740 17.0005
R732 VSS.n1675 VSS.n739 17.0005
R733 VSS.n1675 VSS.n737 17.0005
R734 VSS.n1675 VSS.n736 17.0005
R735 VSS.n1675 VSS.n726 17.0005
R736 VSS.n1675 VSS.n725 17.0005
R737 VSS.n1676 VSS.n1675 17.0005
R738 VSS.n554 VSS.n499 17.0005
R739 VSS.n555 VSS.n499 17.0005
R740 VSS.n557 VSS.n499 17.0005
R741 VSS.n556 VSS.n499 17.0005
R742 VSS.n559 VSS.n499 17.0005
R743 VSS.n558 VSS.n499 17.0005
R744 VSS.n561 VSS.n499 17.0005
R745 VSS.n560 VSS.n499 17.0005
R746 VSS.n563 VSS.n499 17.0005
R747 VSS.n562 VSS.n499 17.0005
R748 VSS.n565 VSS.n499 17.0005
R749 VSS.n564 VSS.n499 17.0005
R750 VSS.n567 VSS.n499 17.0005
R751 VSS.n566 VSS.n499 17.0005
R752 VSS.n569 VSS.n499 17.0005
R753 VSS.n568 VSS.n499 17.0005
R754 VSS.n571 VSS.n499 17.0005
R755 VSS.n570 VSS.n499 17.0005
R756 VSS.n573 VSS.n499 17.0005
R757 VSS.n572 VSS.n499 17.0005
R758 VSS.n2908 VSS.n499 17.0005
R759 VSS.n574 VSS.n499 17.0005
R760 VSS.n575 VSS.n499 17.0005
R761 VSS.n576 VSS.n499 17.0005
R762 VSS.n577 VSS.n499 17.0005
R763 VSS.n578 VSS.n499 17.0005
R764 VSS.n579 VSS.n499 17.0005
R765 VSS.n580 VSS.n499 17.0005
R766 VSS.n581 VSS.n499 17.0005
R767 VSS.n582 VSS.n499 17.0005
R768 VSS.n583 VSS.n499 17.0005
R769 VSS.n584 VSS.n499 17.0005
R770 VSS.n585 VSS.n499 17.0005
R771 VSS.n586 VSS.n499 17.0005
R772 VSS.n2907 VSS.n586 17.0005
R773 VSS.n2907 VSS.n585 17.0005
R774 VSS.n2907 VSS.n584 17.0005
R775 VSS.n2907 VSS.n583 17.0005
R776 VSS.n2907 VSS.n582 17.0005
R777 VSS.n2907 VSS.n581 17.0005
R778 VSS.n2907 VSS.n580 17.0005
R779 VSS.n2907 VSS.n579 17.0005
R780 VSS.n2907 VSS.n578 17.0005
R781 VSS.n2907 VSS.n577 17.0005
R782 VSS.n2907 VSS.n576 17.0005
R783 VSS.n2907 VSS.n575 17.0005
R784 VSS.n2908 VSS.n2907 17.0005
R785 VSS.n2907 VSS.n574 17.0005
R786 VSS.n2907 VSS.n573 17.0005
R787 VSS.n2907 VSS.n572 17.0005
R788 VSS.n2907 VSS.n571 17.0005
R789 VSS.n2907 VSS.n570 17.0005
R790 VSS.n2907 VSS.n569 17.0005
R791 VSS.n2907 VSS.n568 17.0005
R792 VSS.n2907 VSS.n567 17.0005
R793 VSS.n2907 VSS.n566 17.0005
R794 VSS.n2907 VSS.n565 17.0005
R795 VSS.n2907 VSS.n564 17.0005
R796 VSS.n2907 VSS.n563 17.0005
R797 VSS.n2907 VSS.n562 17.0005
R798 VSS.n2907 VSS.n561 17.0005
R799 VSS.n2907 VSS.n560 17.0005
R800 VSS.n2907 VSS.n559 17.0005
R801 VSS.n2907 VSS.n558 17.0005
R802 VSS.n2907 VSS.n557 17.0005
R803 VSS.n2907 VSS.n556 17.0005
R804 VSS.n2907 VSS.n554 17.0005
R805 VSS.n2907 VSS.n555 17.0005
R806 VSS.n856 VSS.n474 17.0005
R807 VSS.n857 VSS.n474 17.0005
R808 VSS.n859 VSS.n474 17.0005
R809 VSS.n861 VSS.n474 17.0005
R810 VSS.n863 VSS.n474 17.0005
R811 VSS.n865 VSS.n474 17.0005
R812 VSS.n868 VSS.n474 17.0005
R813 VSS.n870 VSS.n474 17.0005
R814 VSS.n872 VSS.n474 17.0005
R815 VSS.n887 VSS.n474 17.0005
R816 VSS.n888 VSS.n474 17.0005
R817 VSS.n889 VSS.n474 17.0005
R818 VSS.n890 VSS.n474 17.0005
R819 VSS.n891 VSS.n474 17.0005
R820 VSS.n892 VSS.n474 17.0005
R821 VSS.n893 VSS.n474 17.0005
R822 VSS.n894 VSS.n474 17.0005
R823 VSS.n895 VSS.n474 17.0005
R824 VSS.n896 VSS.n474 17.0005
R825 VSS.n897 VSS.n474 17.0005
R826 VSS.n898 VSS.n474 17.0005
R827 VSS.n899 VSS.n474 17.0005
R828 VSS.n902 VSS.n474 17.0005
R829 VSS.n1675 VSS.n902 17.0005
R830 VSS.n1675 VSS.n899 17.0005
R831 VSS.n1675 VSS.n898 17.0005
R832 VSS.n1675 VSS.n897 17.0005
R833 VSS.n1675 VSS.n896 17.0005
R834 VSS.n1675 VSS.n895 17.0005
R835 VSS.n1675 VSS.n894 17.0005
R836 VSS.n1675 VSS.n893 17.0005
R837 VSS.n1675 VSS.n892 17.0005
R838 VSS.n1675 VSS.n891 17.0005
R839 VSS.n1675 VSS.n890 17.0005
R840 VSS.n1675 VSS.n889 17.0005
R841 VSS.n1675 VSS.n888 17.0005
R842 VSS.n1675 VSS.n500 17.0005
R843 VSS.n1675 VSS.n887 17.0005
R844 VSS.n1675 VSS.n886 17.0005
R845 VSS.n1675 VSS.n872 17.0005
R846 VSS.n1675 VSS.n871 17.0005
R847 VSS.n1675 VSS.n870 17.0005
R848 VSS.n1675 VSS.n869 17.0005
R849 VSS.n1675 VSS.n868 17.0005
R850 VSS.n1675 VSS.n866 17.0005
R851 VSS.n1675 VSS.n865 17.0005
R852 VSS.n1675 VSS.n864 17.0005
R853 VSS.n1675 VSS.n863 17.0005
R854 VSS.n1675 VSS.n862 17.0005
R855 VSS.n1675 VSS.n861 17.0005
R856 VSS.n1675 VSS.n860 17.0005
R857 VSS.n1675 VSS.n859 17.0005
R858 VSS.n1675 VSS.n858 17.0005
R859 VSS.n1675 VSS.n857 17.0005
R860 VSS.n1675 VSS.n855 17.0005
R861 VSS.n1675 VSS.n856 17.0005
R862 VSS.n2923 VSS.n367 17.0005
R863 VSS.n2923 VSS.n364 17.0005
R864 VSS.n2923 VSS.n363 17.0005
R865 VSS.n2923 VSS.n358 17.0005
R866 VSS.n2923 VSS.n357 17.0005
R867 VSS.n2923 VSS.n355 17.0005
R868 VSS.n2923 VSS.n354 17.0005
R869 VSS.n2923 VSS.n352 17.0005
R870 VSS.n2923 VSS.n353 17.0005
R871 VSS.n2923 VSS.n351 17.0005
R872 VSS.n2923 VSS.n350 17.0005
R873 VSS.n2923 VSS.n349 17.0005
R874 VSS.n2923 VSS.n345 17.0005
R875 VSS.n2923 VSS.n343 17.0005
R876 VSS.n2923 VSS.n344 17.0005
R877 VSS.n2923 VSS.n340 17.0005
R878 VSS.n2923 VSS.n339 17.0005
R879 VSS.n2923 VSS.n337 17.0005
R880 VSS.n2923 VSS.t30 17.0005
R881 VSS.n2923 VSS.n335 17.0005
R882 VSS.n2923 VSS.n336 17.0005
R883 VSS.n2923 VSS.n334 17.0005
R884 VSS.n2923 VSS.n333 17.0005
R885 VSS.n2923 VSS.n332 17.0005
R886 VSS.n2923 VSS.n328 17.0005
R887 VSS.n2923 VSS.n326 17.0005
R888 VSS.n2923 VSS.n327 17.0005
R889 VSS.n2923 VSS.n325 17.0005
R890 VSS.n2923 VSS.n324 17.0005
R891 VSS.n2923 VSS.n323 17.0005
R892 VSS.n2923 VSS.n322 17.0005
R893 VSS.n2923 VSS.n321 17.0005
R894 VSS.n2923 VSS.n320 17.0005
R895 VSS.n2923 VSS.n318 17.0005
R896 VSS.n2923 VSS.n317 17.0005
R897 VSS.n2923 VSS.n316 17.0005
R898 VSS.n2913 VSS.n476 17.0005
R899 VSS.n2913 VSS.n477 17.0005
R900 VSS.n2913 VSS.n478 17.0005
R901 VSS.n2913 VSS.n479 17.0005
R902 VSS.n2913 VSS.n480 17.0005
R903 VSS.n2913 VSS.n481 17.0005
R904 VSS.n2913 VSS.n482 17.0005
R905 VSS.n2913 VSS.n483 17.0005
R906 VSS.n2913 VSS.n484 17.0005
R907 VSS.n2913 VSS.n485 17.0005
R908 VSS.n2913 VSS.n486 17.0005
R909 VSS.n2913 VSS.n488 17.0005
R910 VSS.n491 VSS.n475 17.0005
R911 VSS.n488 VSS.n475 17.0005
R912 VSS.n486 VSS.n475 17.0005
R913 VSS.n485 VSS.n475 17.0005
R914 VSS.n484 VSS.n475 17.0005
R915 VSS.n483 VSS.n475 17.0005
R916 VSS.n482 VSS.n475 17.0005
R917 VSS.n481 VSS.n475 17.0005
R918 VSS.n480 VSS.n475 17.0005
R919 VSS.n479 VSS.n475 17.0005
R920 VSS.n478 VSS.n475 17.0005
R921 VSS.n477 VSS.n475 17.0005
R922 VSS.n476 VSS.n475 17.0005
R923 VSS.n588 VSS.n499 17.0005
R924 VSS.n934 VSS.n499 17.0005
R925 VSS.n934 VSS.n933 17.0005
R926 VSS.n2907 VSS.n588 17.0005
R927 VSS.n911 VSS.n905 17.0005
R928 VSS.n911 VSS.n910 17.0005
R929 VSS.n922 VSS.n921 17.0005
R930 VSS.n921 VSS.n917 17.0005
R931 VSS.n935 VSS.n474 17.0005
R932 VSS.n474 VSS.n451 17.0005
R933 VSS.n474 VSS.n453 17.0005
R934 VSS.n900 VSS.n474 17.0005
R935 VSS.n474 VSS.n456 17.0005
R936 VSS.n474 VSS.n457 17.0005
R937 VSS.n474 VSS.n458 17.0005
R938 VSS.n474 VSS.n459 17.0005
R939 VSS.n474 VSS.n460 17.0005
R940 VSS.n474 VSS.n461 17.0005
R941 VSS.n474 VSS.n462 17.0005
R942 VSS.n474 VSS.n463 17.0005
R943 VSS.n474 VSS.n464 17.0005
R944 VSS.n474 VSS.n465 17.0005
R945 VSS.n474 VSS.n466 17.0005
R946 VSS.n474 VSS.n467 17.0005
R947 VSS.n474 VSS.n469 17.0005
R948 VSS.n474 VSS.n470 17.0005
R949 VSS.n2916 VSS.n474 17.0005
R950 VSS.n2917 VSS.n2916 17.0005
R951 VSS.n2917 VSS.n470 17.0005
R952 VSS.n2917 VSS.n469 17.0005
R953 VSS.n2917 VSS.n467 17.0005
R954 VSS.n2917 VSS.n466 17.0005
R955 VSS.n2917 VSS.n465 17.0005
R956 VSS.n2917 VSS.n464 17.0005
R957 VSS.n2917 VSS.n463 17.0005
R958 VSS.n2917 VSS.n462 17.0005
R959 VSS.n2917 VSS.n461 17.0005
R960 VSS.n2917 VSS.n460 17.0005
R961 VSS.n2917 VSS.n459 17.0005
R962 VSS.n2917 VSS.n458 17.0005
R963 VSS.n2917 VSS.n457 17.0005
R964 VSS.n2917 VSS.n456 17.0005
R965 VSS.n2917 VSS.n455 17.0005
R966 VSS.n2917 VSS.n453 17.0005
R967 VSS.n2917 VSS.n451 17.0005
R968 VSS.n1675 VSS.n935 17.0005
R969 VSS.n2926 VSS.n74 17.0005
R970 VSS.n2926 VSS.n75 17.0005
R971 VSS.n2926 VSS.n76 17.0005
R972 VSS.n2926 VSS.n78 17.0005
R973 VSS.n2926 VSS.n79 17.0005
R974 VSS.n2926 VSS.n81 17.0005
R975 VSS.n2926 VSS.n80 17.0005
R976 VSS.n2926 VSS.n82 17.0005
R977 VSS.n2926 VSS.n83 17.0005
R978 VSS.n2926 VSS.n85 17.0005
R979 VSS.n2926 VSS.n84 17.0005
R980 VSS.n2926 VSS.n86 17.0005
R981 VSS.n2926 VSS.n87 17.0005
R982 VSS.n2926 VSS.n89 17.0005
R983 VSS.n2926 VSS.n88 17.0005
R984 VSS.n2926 VSS.n90 17.0005
R985 VSS.n2926 VSS.n91 17.0005
R986 VSS.n2926 VSS.n93 17.0005
R987 VSS.n2926 VSS.n92 17.0005
R988 VSS.n2926 VSS.n94 17.0005
R989 VSS.n2926 VSS.n95 17.0005
R990 VSS.n2926 VSS.n97 17.0005
R991 VSS.n2926 VSS.n96 17.0005
R992 VSS.n2926 VSS.n98 17.0005
R993 VSS.n2926 VSS.n99 17.0005
R994 VSS.n2926 VSS.n101 17.0005
R995 VSS.n2926 VSS.n100 17.0005
R996 VSS.n2926 VSS.n102 17.0005
R997 VSS.n2926 VSS.n103 17.0005
R998 VSS.n2926 VSS.n105 17.0005
R999 VSS.n2926 VSS.n104 17.0005
R1000 VSS.n2926 VSS.n106 17.0005
R1001 VSS.n2926 VSS.n107 17.0005
R1002 VSS.n2926 VSS.n109 17.0005
R1003 VSS.n2926 VSS.n108 17.0005
R1004 VSS.n2926 VSS.n110 17.0005
R1005 VSS.n2926 VSS.n111 17.0005
R1006 VSS.n2926 VSS.n113 17.0005
R1007 VSS.n2926 VSS.n112 17.0005
R1008 VSS.n2926 VSS.n114 17.0005
R1009 VSS.n2926 VSS.n115 17.0005
R1010 VSS.n2926 VSS.n117 17.0005
R1011 VSS.n2926 VSS.n116 17.0005
R1012 VSS.n2926 VSS.n118 17.0005
R1013 VSS.n2926 VSS.n119 17.0005
R1014 VSS.n2926 VSS.n121 17.0005
R1015 VSS.n2926 VSS.n120 17.0005
R1016 VSS.n2926 VSS.n122 17.0005
R1017 VSS.n2926 VSS.n123 17.0005
R1018 VSS.n2926 VSS.n125 17.0005
R1019 VSS.n2926 VSS.n124 17.0005
R1020 VSS.n2926 VSS.n126 17.0005
R1021 VSS.n2926 VSS.n127 17.0005
R1022 VSS.n2926 VSS.n129 17.0005
R1023 VSS.n2926 VSS.n128 17.0005
R1024 VSS.n2926 VSS.n130 17.0005
R1025 VSS.n2926 VSS.n131 17.0005
R1026 VSS.n2926 VSS.n133 17.0005
R1027 VSS.n2926 VSS.n132 17.0005
R1028 VSS.n2926 VSS.n134 17.0005
R1029 VSS.n2926 VSS.n135 17.0005
R1030 VSS.n2926 VSS.n137 17.0005
R1031 VSS.n2926 VSS.n136 17.0005
R1032 VSS.n2926 VSS.n138 17.0005
R1033 VSS.n2926 VSS.n139 17.0005
R1034 VSS.n2926 VSS.n141 17.0005
R1035 VSS.n2926 VSS.n140 17.0005
R1036 VSS.n2926 VSS.n142 17.0005
R1037 VSS.n2926 VSS.n143 17.0005
R1038 VSS.n2926 VSS.n145 17.0005
R1039 VSS.n2926 VSS.n144 17.0005
R1040 VSS.n2926 VSS.n146 17.0005
R1041 VSS.n2926 VSS.n147 17.0005
R1042 VSS.n2926 VSS.n149 17.0005
R1043 VSS.n2926 VSS.n148 17.0005
R1044 VSS.n2926 VSS.n150 17.0005
R1045 VSS.n2926 VSS.n151 17.0005
R1046 VSS.n2926 VSS.n153 17.0005
R1047 VSS.n2926 VSS.n152 17.0005
R1048 VSS.n2926 VSS.n154 17.0005
R1049 VSS.n2926 VSS.n155 17.0005
R1050 VSS.n2926 VSS.n157 17.0005
R1051 VSS.n2926 VSS.n156 17.0005
R1052 VSS.n2926 VSS.n158 17.0005
R1053 VSS.n2926 VSS.n159 17.0005
R1054 VSS.n2926 VSS.n161 17.0005
R1055 VSS.n2926 VSS.n160 17.0005
R1056 VSS.n2926 VSS.n162 17.0005
R1057 VSS.n2926 VSS.n163 17.0005
R1058 VSS.n2926 VSS.n165 17.0005
R1059 VSS.n2926 VSS.n164 17.0005
R1060 VSS.n2926 VSS.n166 17.0005
R1061 VSS.n2926 VSS.n167 17.0005
R1062 VSS.n2926 VSS.n169 17.0005
R1063 VSS.n2926 VSS.n168 17.0005
R1064 VSS.n2926 VSS.n170 17.0005
R1065 VSS.n2926 VSS.n171 17.0005
R1066 VSS.n2926 VSS.n173 17.0005
R1067 VSS.n2926 VSS.n172 17.0005
R1068 VSS.n2926 VSS.n174 17.0005
R1069 VSS.n2926 VSS.n175 17.0005
R1070 VSS.n2926 VSS.n177 17.0005
R1071 VSS.n2926 VSS.n176 17.0005
R1072 VSS.n2926 VSS.n179 17.0005
R1073 VSS.n2926 VSS.n180 17.0005
R1074 VSS.n2926 VSS.n181 17.0005
R1075 VSS.n2926 VSS.n2925 17.0005
R1076 VSS.n2926 VSS.n233 17.0005
R1077 VSS.n2926 VSS.n232 17.0005
R1078 VSS.n2926 VSS.n231 17.0005
R1079 VSS.n2926 VSS.n205 17.0005
R1080 VSS.n2926 VSS.n204 17.0005
R1081 VSS.n2926 VSS.n203 17.0005
R1082 VSS.n2926 VSS.n202 17.0005
R1083 VSS.n2926 VSS.n201 17.0005
R1084 VSS.n2926 VSS.n200 17.0005
R1085 VSS.n2926 VSS.n199 17.0005
R1086 VSS.n2926 VSS.n198 17.0005
R1087 VSS.n2926 VSS.n197 17.0005
R1088 VSS.n2926 VSS.n196 17.0005
R1089 VSS.n2926 VSS.n195 17.0005
R1090 VSS.n2926 VSS.n194 17.0005
R1091 VSS.n2926 VSS.n193 17.0005
R1092 VSS.n2926 VSS.n192 17.0005
R1093 VSS.n2926 VSS.n191 17.0005
R1094 VSS.n2926 VSS.n190 17.0005
R1095 VSS.n2926 VSS.n189 17.0005
R1096 VSS.n2926 VSS.n186 17.0005
R1097 VSS.n2926 VSS.n185 17.0005
R1098 VSS.n2926 VSS.n184 17.0005
R1099 VSS.n2926 VSS.n183 17.0005
R1100 VSS.n1289 VSS.n1288 17.0005
R1101 VSS.n1288 VSS.n1287 17.0005
R1102 VSS.n1466 VSS.n1465 17.0005
R1103 VSS.n1465 VSS.n1464 17.0005
R1104 VSS.n1411 VSS.n1410 17.0005
R1105 VSS.n1412 VSS.n1411 17.0005
R1106 VSS.n1416 VSS.n1415 17.0005
R1107 VSS.n1417 VSS.n1416 17.0005
R1108 VSS.n1421 VSS.n1420 17.0005
R1109 VSS.n1422 VSS.n1421 17.0005
R1110 VSS.n1426 VSS.n1425 17.0005
R1111 VSS.n1427 VSS.n1426 17.0005
R1112 VSS.n1432 VSS.n1431 17.0005
R1113 VSS.n1433 VSS.n1432 17.0005
R1114 VSS.n1437 VSS.n1436 17.0005
R1115 VSS.n1438 VSS.n1437 17.0005
R1116 VSS.n1442 VSS.n1441 17.0005
R1117 VSS.n1443 VSS.n1442 17.0005
R1118 VSS.n1447 VSS.n1446 17.0005
R1119 VSS.n1448 VSS.n1447 17.0005
R1120 VSS.n1453 VSS.n1452 17.0005
R1121 VSS.n1454 VSS.n1453 17.0005
R1122 VSS.n1404 VSS.n1403 17.0005
R1123 VSS.n1403 VSS.n1402 17.0005
R1124 VSS.n74 VSS.n70 17.0005
R1125 VSS.n75 VSS.n70 17.0005
R1126 VSS.n76 VSS.n70 17.0005
R1127 VSS.n1285 VSS.n70 17.0005
R1128 VSS.n79 VSS.n70 17.0005
R1129 VSS.n1468 VSS.n70 17.0005
R1130 VSS.n80 VSS.n70 17.0005
R1131 VSS.n1471 VSS.n70 17.0005
R1132 VSS.n83 VSS.n70 17.0005
R1133 VSS.n1470 VSS.n70 17.0005
R1134 VSS.n84 VSS.n70 17.0005
R1135 VSS.n1473 VSS.n70 17.0005
R1136 VSS.n87 VSS.n70 17.0005
R1137 VSS.n1476 VSS.n70 17.0005
R1138 VSS.n88 VSS.n70 17.0005
R1139 VSS.n1478 VSS.n70 17.0005
R1140 VSS.n91 VSS.n70 17.0005
R1141 VSS.n1480 VSS.n70 17.0005
R1142 VSS.n92 VSS.n70 17.0005
R1143 VSS.n1482 VSS.n70 17.0005
R1144 VSS.n95 VSS.n70 17.0005
R1145 VSS.n1484 VSS.n70 17.0005
R1146 VSS.n96 VSS.n70 17.0005
R1147 VSS.n1486 VSS.n70 17.0005
R1148 VSS.n99 VSS.n70 17.0005
R1149 VSS.n1488 VSS.n70 17.0005
R1150 VSS.n100 VSS.n70 17.0005
R1151 VSS.n1490 VSS.n70 17.0005
R1152 VSS.n103 VSS.n70 17.0005
R1153 VSS.n1492 VSS.n70 17.0005
R1154 VSS.n104 VSS.n70 17.0005
R1155 VSS.n1494 VSS.n70 17.0005
R1156 VSS.n107 VSS.n70 17.0005
R1157 VSS.n1496 VSS.n70 17.0005
R1158 VSS.n108 VSS.n70 17.0005
R1159 VSS.n1293 VSS.n70 17.0005
R1160 VSS.n111 VSS.n70 17.0005
R1161 VSS.n1569 VSS.n70 17.0005
R1162 VSS.n112 VSS.n70 17.0005
R1163 VSS.n1498 VSS.n70 17.0005
R1164 VSS.n115 VSS.n70 17.0005
R1165 VSS.n1501 VSS.n70 17.0005
R1166 VSS.n116 VSS.n70 17.0005
R1167 VSS.n1503 VSS.n70 17.0005
R1168 VSS.n119 VSS.n70 17.0005
R1169 VSS.n1505 VSS.n70 17.0005
R1170 VSS.n120 VSS.n70 17.0005
R1171 VSS.n1507 VSS.n70 17.0005
R1172 VSS.n123 VSS.n70 17.0005
R1173 VSS.n1509 VSS.n70 17.0005
R1174 VSS.n124 VSS.n70 17.0005
R1175 VSS.n1511 VSS.n70 17.0005
R1176 VSS.n127 VSS.n70 17.0005
R1177 VSS.n1513 VSS.n70 17.0005
R1178 VSS.n128 VSS.n70 17.0005
R1179 VSS.n1515 VSS.n70 17.0005
R1180 VSS.n131 VSS.n70 17.0005
R1181 VSS.n1517 VSS.n70 17.0005
R1182 VSS.n132 VSS.n70 17.0005
R1183 VSS.n1519 VSS.n70 17.0005
R1184 VSS.n135 VSS.n70 17.0005
R1185 VSS.n1521 VSS.n70 17.0005
R1186 VSS.n136 VSS.n70 17.0005
R1187 VSS.n1523 VSS.n70 17.0005
R1188 VSS.n139 VSS.n70 17.0005
R1189 VSS.n1525 VSS.n70 17.0005
R1190 VSS.n140 VSS.n70 17.0005
R1191 VSS.n1528 VSS.n70 17.0005
R1192 VSS.n143 VSS.n70 17.0005
R1193 VSS.n1530 VSS.n70 17.0005
R1194 VSS.n144 VSS.n70 17.0005
R1195 VSS.n1532 VSS.n70 17.0005
R1196 VSS.n147 VSS.n70 17.0005
R1197 VSS.n1534 VSS.n70 17.0005
R1198 VSS.n148 VSS.n70 17.0005
R1199 VSS.n1536 VSS.n70 17.0005
R1200 VSS.n151 VSS.n70 17.0005
R1201 VSS.n1538 VSS.n70 17.0005
R1202 VSS.n152 VSS.n70 17.0005
R1203 VSS.n1540 VSS.n70 17.0005
R1204 VSS.n155 VSS.n70 17.0005
R1205 VSS.n1542 VSS.n70 17.0005
R1206 VSS.n156 VSS.n70 17.0005
R1207 VSS.n1544 VSS.n70 17.0005
R1208 VSS.n159 VSS.n70 17.0005
R1209 VSS.n1546 VSS.n70 17.0005
R1210 VSS.n160 VSS.n70 17.0005
R1211 VSS.n1548 VSS.n70 17.0005
R1212 VSS.n163 VSS.n70 17.0005
R1213 VSS.n1550 VSS.n70 17.0005
R1214 VSS.n164 VSS.n70 17.0005
R1215 VSS.n1552 VSS.n70 17.0005
R1216 VSS.n167 VSS.n70 17.0005
R1217 VSS.n1557 VSS.n70 17.0005
R1218 VSS.n168 VSS.n70 17.0005
R1219 VSS.n1559 VSS.n70 17.0005
R1220 VSS.n171 VSS.n70 17.0005
R1221 VSS.n1555 VSS.n70 17.0005
R1222 VSS.n172 VSS.n70 17.0005
R1223 VSS.n1566 VSS.n70 17.0005
R1224 VSS.n175 VSS.n70 17.0005
R1225 VSS.n176 VSS.n70 17.0005
R1226 VSS.n179 VSS.n70 17.0005
R1227 VSS.n180 VSS.n70 17.0005
R1228 VSS.n181 VSS.n70 17.0005
R1229 VSS.n2925 VSS.n70 17.0005
R1230 VSS.n2927 VSS.n70 17.0005
R1231 VSS.n2923 VSS.n315 17.0005
R1232 VSS.n2923 VSS.n314 17.0005
R1233 VSS.n2923 VSS.n313 17.0005
R1234 VSS.n2923 VSS.n312 17.0005
R1235 VSS.n2923 VSS.n311 17.0005
R1236 VSS.n2923 VSS.n310 17.0005
R1237 VSS.n2923 VSS.n309 17.0005
R1238 VSS.n2923 VSS.n308 17.0005
R1239 VSS.n2923 VSS.n307 17.0005
R1240 VSS.n2923 VSS.n305 17.0005
R1241 VSS.n2923 VSS.n303 17.0005
R1242 VSS.n2923 VSS.n301 17.0005
R1243 VSS.n2923 VSS.n302 17.0005
R1244 VSS.n2923 VSS.n295 17.0005
R1245 VSS.n2923 VSS.n294 17.0005
R1246 VSS.n2923 VSS.n292 17.0005
R1247 VSS.n2923 VSS.n293 17.0005
R1248 VSS.n2923 VSS.n291 17.0005
R1249 VSS.n2923 VSS.n290 17.0005
R1250 VSS.n2923 VSS.t32 17.0005
R1251 VSS.n2923 VSS.n288 17.0005
R1252 VSS.n2923 VSS.n286 17.0005
R1253 VSS.n2923 VSS.n287 17.0005
R1254 VSS.n2923 VSS.n284 17.0005
R1255 VSS.n2923 VSS.n281 17.0005
R1256 VSS.n2923 VSS.n280 17.0005
R1257 VSS.n2923 VSS.n273 17.0005
R1258 VSS.n2923 VSS.n271 17.0005
R1259 VSS.n2923 VSS.n272 17.0005
R1260 VSS.n2923 VSS.n270 17.0005
R1261 VSS.n2923 VSS.n269 17.0005
R1262 VSS.n2923 VSS.n267 17.0005
R1263 VSS.n2923 VSS.n268 17.0005
R1264 VSS.n2923 VSS.n266 17.0005
R1265 VSS.n2923 VSS.n262 17.0005
R1266 VSS.n2923 VSS.n260 17.0005
R1267 VSS.n2923 VSS.n261 17.0005
R1268 VSS.n2923 VSS.n257 17.0005
R1269 VSS.n2923 VSS.n256 17.0005
R1270 VSS.n2924 VSS.n2923 17.0005
R1271 VSS.n382 VSS.n234 17.0005
R1272 VSS.n367 VSS.n234 17.0005
R1273 VSS.n364 VSS.n234 17.0005
R1274 VSS.n361 VSS.n234 17.0005
R1275 VSS.n363 VSS.n234 17.0005
R1276 VSS.n359 VSS.n234 17.0005
R1277 VSS.n358 VSS.n234 17.0005
R1278 VSS.n1385 VSS.n234 17.0005
R1279 VSS.n357 VSS.n234 17.0005
R1280 VSS.n355 VSS.n234 17.0005
R1281 VSS.n354 VSS.n234 17.0005
R1282 VSS.n352 VSS.n234 17.0005
R1283 VSS.n353 VSS.n234 17.0005
R1284 VSS.n351 VSS.n234 17.0005
R1285 VSS.n350 VSS.n234 17.0005
R1286 VSS.n1388 VSS.n234 17.0005
R1287 VSS.n349 VSS.n234 17.0005
R1288 VSS.n347 VSS.n234 17.0005
R1289 VSS.n345 VSS.n234 17.0005
R1290 VSS.n343 VSS.n234 17.0005
R1291 VSS.n344 VSS.n234 17.0005
R1292 VSS.n341 VSS.n234 17.0005
R1293 VSS.n340 VSS.n234 17.0005
R1294 VSS.n1368 VSS.n234 17.0005
R1295 VSS.n339 VSS.n234 17.0005
R1296 VSS.n337 VSS.n234 17.0005
R1297 VSS.t30 VSS.n234 17.0005
R1298 VSS.n335 VSS.n234 17.0005
R1299 VSS.n336 VSS.n234 17.0005
R1300 VSS.n334 VSS.n234 17.0005
R1301 VSS.n333 VSS.n234 17.0005
R1302 VSS.n1371 VSS.n234 17.0005
R1303 VSS.n332 VSS.n234 17.0005
R1304 VSS.n330 VSS.n234 17.0005
R1305 VSS.n328 VSS.n234 17.0005
R1306 VSS.n326 VSS.n234 17.0005
R1307 VSS.n327 VSS.n234 17.0005
R1308 VSS.n325 VSS.n234 17.0005
R1309 VSS.n324 VSS.n234 17.0005
R1310 VSS.n323 VSS.n234 17.0005
R1311 VSS.n322 VSS.n234 17.0005
R1312 VSS.n321 VSS.n234 17.0005
R1313 VSS.n320 VSS.n234 17.0005
R1314 VSS.n318 VSS.n234 17.0005
R1315 VSS.n317 VSS.n234 17.0005
R1316 VSS.n316 VSS.n234 17.0005
R1317 VSS.n315 VSS.n234 17.0005
R1318 VSS.n314 VSS.n234 17.0005
R1319 VSS.n313 VSS.n234 17.0005
R1320 VSS.n312 VSS.n234 17.0005
R1321 VSS.n311 VSS.n234 17.0005
R1322 VSS.n310 VSS.n234 17.0005
R1323 VSS.n309 VSS.n234 17.0005
R1324 VSS.n308 VSS.n234 17.0005
R1325 VSS.n307 VSS.n234 17.0005
R1326 VSS.n305 VSS.n234 17.0005
R1327 VSS.n303 VSS.n234 17.0005
R1328 VSS.n301 VSS.n234 17.0005
R1329 VSS.n302 VSS.n234 17.0005
R1330 VSS.n295 VSS.n234 17.0005
R1331 VSS.n294 VSS.n234 17.0005
R1332 VSS.n292 VSS.n234 17.0005
R1333 VSS.n293 VSS.n234 17.0005
R1334 VSS.n291 VSS.n234 17.0005
R1335 VSS.n290 VSS.n234 17.0005
R1336 VSS.n298 VSS.n234 17.0005
R1337 VSS.t32 VSS.n234 17.0005
R1338 VSS.n1309 VSS.n234 17.0005
R1339 VSS.n288 VSS.n234 17.0005
R1340 VSS.n286 VSS.n234 17.0005
R1341 VSS.n287 VSS.n234 17.0005
R1342 VSS.n284 VSS.n234 17.0005
R1343 VSS.n281 VSS.n234 17.0005
R1344 VSS.n282 VSS.n234 17.0005
R1345 VSS.n280 VSS.n234 17.0005
R1346 VSS.n278 VSS.n234 17.0005
R1347 VSS.n273 VSS.n234 17.0005
R1348 VSS.n271 VSS.n234 17.0005
R1349 VSS.n272 VSS.n234 17.0005
R1350 VSS.n270 VSS.n234 17.0005
R1351 VSS.n269 VSS.n234 17.0005
R1352 VSS.n267 VSS.n234 17.0005
R1353 VSS.n268 VSS.n234 17.0005
R1354 VSS.n266 VSS.n234 17.0005
R1355 VSS.n262 VSS.n234 17.0005
R1356 VSS.n260 VSS.n234 17.0005
R1357 VSS.n261 VSS.n234 17.0005
R1358 VSS.n258 VSS.n234 17.0005
R1359 VSS.n257 VSS.n234 17.0005
R1360 VSS.n256 VSS.n234 17.0005
R1361 VSS.n2924 VSS.n234 17.0005
R1362 VSS.n251 VSS.n234 17.0005
R1363 VSS.n2688 VSS.n2687 17.0005
R1364 VSS.n2689 VSS.n2688 17.0005
R1365 VSS.n2833 VSS.n647 17.0005
R1366 VSS.n2829 VSS.n647 17.0005
R1367 VSS.n2827 VSS.n647 17.0005
R1368 VSS.n2825 VSS.n647 17.0005
R1369 VSS.n2823 VSS.n647 17.0005
R1370 VSS.n2821 VSS.n647 17.0005
R1371 VSS.n2819 VSS.n647 17.0005
R1372 VSS.n2817 VSS.n647 17.0005
R1373 VSS.n2815 VSS.n647 17.0005
R1374 VSS.n2813 VSS.n647 17.0005
R1375 VSS.n2811 VSS.n647 17.0005
R1376 VSS.n2809 VSS.n647 17.0005
R1377 VSS.n2807 VSS.n647 17.0005
R1378 VSS.n2805 VSS.n647 17.0005
R1379 VSS.n2803 VSS.n647 17.0005
R1380 VSS.n2801 VSS.n647 17.0005
R1381 VSS.n2799 VSS.n647 17.0005
R1382 VSS.n2797 VSS.n647 17.0005
R1383 VSS.n2795 VSS.n647 17.0005
R1384 VSS.n2793 VSS.n647 17.0005
R1385 VSS.n2789 VSS.n647 17.0005
R1386 VSS.n2787 VSS.n647 17.0005
R1387 VSS.n2785 VSS.n647 17.0005
R1388 VSS.n2781 VSS.n647 17.0005
R1389 VSS.n2761 VSS.n2760 17.0005
R1390 VSS.n2760 VSS.n2759 17.0005
R1391 VSS.n2755 VSS.n2754 17.0005
R1392 VSS.n2754 VSS.n2753 17.0005
R1393 VSS.n2442 VSS.n2440 17.0005
R1394 VSS.n2442 VSS.n2441 17.0005
R1395 VSS.n2462 VSS.n2460 17.0005
R1396 VSS.n2462 VSS.n2461 17.0005
R1397 VSS.n2466 VSS.n2464 17.0005
R1398 VSS.n2466 VSS.n2465 17.0005
R1399 VSS.n2480 VSS.n2479 17.0005
R1400 VSS.n2481 VSS.n2480 17.0005
R1401 VSS.n2484 VSS.n2483 17.0005
R1402 VSS.n2485 VSS.n2484 17.0005
R1403 VSS.n2488 VSS.n2487 17.0005
R1404 VSS.n2489 VSS.n2488 17.0005
R1405 VSS.n2492 VSS.n2491 17.0005
R1406 VSS.n2493 VSS.n2492 17.0005
R1407 VSS.n2496 VSS.n2495 17.0005
R1408 VSS.n2497 VSS.n2496 17.0005
R1409 VSS.n2500 VSS.n2499 17.0005
R1410 VSS.n2501 VSS.n2500 17.0005
R1411 VSS.n2515 VSS.n647 17.0005
R1412 VSS.n1909 VSS.n1812 17.0005
R1413 VSS.n1909 VSS.n1811 17.0005
R1414 VSS.n1909 VSS.n1810 17.0005
R1415 VSS.n1909 VSS.n1809 17.0005
R1416 VSS.n1909 VSS.n1808 17.0005
R1417 VSS.n1909 VSS.n1807 17.0005
R1418 VSS.n1909 VSS.n1806 17.0005
R1419 VSS.n1909 VSS.n1805 17.0005
R1420 VSS.n1909 VSS.n1804 17.0005
R1421 VSS.n1909 VSS.n1803 17.0005
R1422 VSS.n1909 VSS.n1802 17.0005
R1423 VSS.n1909 VSS.n1801 17.0005
R1424 VSS.n1909 VSS.n1800 17.0005
R1425 VSS.n1909 VSS.n1799 17.0005
R1426 VSS.n1909 VSS.n1798 17.0005
R1427 VSS.n1909 VSS.n1797 17.0005
R1428 VSS.n1909 VSS.n1796 17.0005
R1429 VSS.n1909 VSS.n1795 17.0005
R1430 VSS.n1909 VSS.n1794 17.0005
R1431 VSS.n1909 VSS.n1793 17.0005
R1432 VSS.n1909 VSS.n1786 17.0005
R1433 VSS.n1147 VSS.n1129 17.0005
R1434 VSS.n1141 VSS.n1129 17.0005
R1435 VSS.n1150 VSS.n1129 17.0005
R1436 VSS.n1140 VSS.n1129 17.0005
R1437 VSS.n1154 VSS.n1129 17.0005
R1438 VSS.n1135 VSS.n1129 17.0005
R1439 VSS.n1157 VSS.n1129 17.0005
R1440 VSS.n1159 VSS.n1129 17.0005
R1441 VSS.n1129 VSS.n1126 17.0005
R1442 VSS.n1129 VSS.n1124 17.0005
R1443 VSS.n1129 VSS.n1122 17.0005
R1444 VSS.n1129 VSS.n1120 17.0005
R1445 VSS.n1129 VSS.n1023 17.0005
R1446 VSS.n1129 VSS.n1021 17.0005
R1447 VSS.n1129 VSS.n1019 17.0005
R1448 VSS.n1129 VSS.n1017 17.0005
R1449 VSS.n1129 VSS.n1015 17.0005
R1450 VSS.n1129 VSS.n1013 17.0005
R1451 VSS.n1164 VSS.n1008 17.0005
R1452 VSS.n1163 VSS.n1162 17.0005
R1453 VSS.n1162 VSS.n1161 17.0005
R1454 VSS.n1159 VSS.n1158 17.0005
R1455 VSS.n1158 VSS.n1157 17.0005
R1456 VSS.n1153 VSS.n1135 17.0005
R1457 VSS.n1154 VSS.n1153 17.0005
R1458 VSS.n1151 VSS.n1140 17.0005
R1459 VSS.n1151 VSS.n1150 17.0005
R1460 VSS.n1148 VSS.n1141 17.0005
R1461 VSS.n1148 VSS.n1147 17.0005
R1462 VSS.n1013 VSS.n1008 17.0005
R1463 VSS.n1015 VSS.n1008 17.0005
R1464 VSS.n1017 VSS.n1008 17.0005
R1465 VSS.n1019 VSS.n1008 17.0005
R1466 VSS.n1021 VSS.n1008 17.0005
R1467 VSS.n1023 VSS.n1008 17.0005
R1468 VSS.n1120 VSS.n1008 17.0005
R1469 VSS.n1122 VSS.n1008 17.0005
R1470 VSS.n1124 VSS.n1008 17.0005
R1471 VSS.n1126 VSS.n1008 17.0005
R1472 VSS.n1237 VSS.n499 17.0005
R1473 VSS.n1214 VSS.n499 17.0005
R1474 VSS.n1212 VSS.n499 17.0005
R1475 VSS.n1207 VSS.n499 17.0005
R1476 VSS.n1205 VSS.n499 17.0005
R1477 VSS.n1200 VSS.n499 17.0005
R1478 VSS.n1198 VSS.n499 17.0005
R1479 VSS.n1193 VSS.n499 17.0005
R1480 VSS.n1191 VSS.n499 17.0005
R1481 VSS.n1186 VSS.n499 17.0005
R1482 VSS.n1184 VSS.n499 17.0005
R1483 VSS.n1175 VSS.n499 17.0005
R1484 VSS.n1173 VSS.n499 17.0005
R1485 VSS.n1179 VSS.n499 17.0005
R1486 VSS.n1176 VSS.n499 17.0005
R1487 VSS.n2884 VSS.n499 17.0005
R1488 VSS.n610 VSS.n499 17.0005
R1489 VSS.n2888 VSS.n499 17.0005
R1490 VSS.n1609 VSS.n499 17.0005
R1491 VSS.n1612 VSS.n499 17.0005
R1492 VSS.n965 VSS.n499 17.0005
R1493 VSS.n1616 VSS.n499 17.0005
R1494 VSS.n963 VSS.n499 17.0005
R1495 VSS.n1620 VSS.n499 17.0005
R1496 VSS.n961 VSS.n499 17.0005
R1497 VSS.n1624 VSS.n499 17.0005
R1498 VSS.n959 VSS.n499 17.0005
R1499 VSS.n1628 VSS.n499 17.0005
R1500 VSS.n957 VSS.n499 17.0005
R1501 VSS.n1632 VSS.n499 17.0005
R1502 VSS.n955 VSS.n499 17.0005
R1503 VSS.n1636 VSS.n499 17.0005
R1504 VSS.n953 VSS.n499 17.0005
R1505 VSS.n1640 VSS.n499 17.0005
R1506 VSS.n951 VSS.n499 17.0005
R1507 VSS.n1644 VSS.n499 17.0005
R1508 VSS.n949 VSS.n499 17.0005
R1509 VSS.n1649 VSS.n499 17.0005
R1510 VSS.n947 VSS.n499 17.0005
R1511 VSS.n1653 VSS.n499 17.0005
R1512 VSS.n945 VSS.n499 17.0005
R1513 VSS.n1657 VSS.n499 17.0005
R1514 VSS.n943 VSS.n499 17.0005
R1515 VSS.n1661 VSS.n499 17.0005
R1516 VSS.n941 VSS.n499 17.0005
R1517 VSS.n1665 VSS.n499 17.0005
R1518 VSS.n939 VSS.n499 17.0005
R1519 VSS.n1669 VSS.n499 17.0005
R1520 VSS.n937 VSS.n499 17.0005
R1521 VSS.n1673 VSS.n499 17.0005
R1522 VSS.n936 VSS.n499 17.0005
R1523 VSS.n680 VSS.n499 17.0005
R1524 VSS.n1127 VSS.n499 17.0005
R1525 VSS.n1125 VSS.n499 17.0005
R1526 VSS.n1221 VSS.n499 17.0005
R1527 VSS.n1009 VSS.n499 17.0005
R1528 VSS.n1219 VSS.n499 17.0005
R1529 VSS.n1123 VSS.n499 17.0005
R1530 VSS.n1121 VSS.n499 17.0005
R1531 VSS.n1119 VSS.n499 17.0005
R1532 VSS.n1022 VSS.n499 17.0005
R1533 VSS.n1020 VSS.n499 17.0005
R1534 VSS.n1231 VSS.n499 17.0005
R1535 VSS.n1018 VSS.n499 17.0005
R1536 VSS.n1007 VSS.n499 17.0005
R1537 VSS.n1016 VSS.n499 17.0005
R1538 VSS.n1014 VSS.n499 17.0005
R1539 VSS.n1012 VSS.n499 17.0005
R1540 VSS.n672 VSS.n499 17.0005
R1541 VSS.n2890 VSS.n2889 17.0005
R1542 VSS.n2889 VSS.n2888 17.0005
R1543 VSS.n2883 VSS.n610 17.0005
R1544 VSS.n2884 VSS.n2883 17.0005
R1545 VSS.n1176 VSS.n614 17.0005
R1546 VSS.n1179 VSS.n614 17.0005
R1547 VSS.n1174 VSS.n1173 17.0005
R1548 VSS.n1175 VSS.n1174 17.0005
R1549 VSS.n1185 VSS.n1184 17.0005
R1550 VSS.n1186 VSS.n1185 17.0005
R1551 VSS.n1192 VSS.n1191 17.0005
R1552 VSS.n1193 VSS.n1192 17.0005
R1553 VSS.n1199 VSS.n1198 17.0005
R1554 VSS.n1200 VSS.n1199 17.0005
R1555 VSS.n1206 VSS.n1205 17.0005
R1556 VSS.n1207 VSS.n1206 17.0005
R1557 VSS.n1213 VSS.n1212 17.0005
R1558 VSS.n1214 VSS.n1213 17.0005
R1559 VSS.n1237 VSS.n1236 17.0005
R1560 VSS.n1236 VSS.n1235 17.0005
R1561 VSS.n706 VSS.n474 17.0005
R1562 VSS.n704 VSS.n474 17.0005
R1563 VSS.n703 VSS.n474 17.0005
R1564 VSS.n701 VSS.n474 17.0005
R1565 VSS.n699 VSS.n474 17.0005
R1566 VSS.n698 VSS.n474 17.0005
R1567 VSS.n696 VSS.n474 17.0005
R1568 VSS.n693 VSS.n474 17.0005
R1569 VSS.n692 VSS.n474 17.0005
R1570 VSS.n690 VSS.n474 17.0005
R1571 VSS.n688 VSS.n474 17.0005
R1572 VSS.n687 VSS.n474 17.0005
R1573 VSS.n2877 VSS.n474 17.0005
R1574 VSS.n685 VSS.n474 17.0005
R1575 VSS.n683 VSS.n474 17.0005
R1576 VSS.n1675 VSS.n723 17.0005
R1577 VSS.n1675 VSS.n1674 17.0005
R1578 VSS.n1672 VSS.n1671 17.0005
R1579 VSS.n1671 VSS.n1670 17.0005
R1580 VSS.n1668 VSS.n1667 17.0005
R1581 VSS.n1667 VSS.n1666 17.0005
R1582 VSS.n1664 VSS.n1663 17.0005
R1583 VSS.n1663 VSS.n1662 17.0005
R1584 VSS.n1660 VSS.n1659 17.0005
R1585 VSS.n1659 VSS.n1658 17.0005
R1586 VSS.n1656 VSS.n1655 17.0005
R1587 VSS.n1655 VSS.n1654 17.0005
R1588 VSS.n1652 VSS.n1651 17.0005
R1589 VSS.n1651 VSS.n1650 17.0005
R1590 VSS.n1647 VSS.n1646 17.0005
R1591 VSS.n1646 VSS.n1645 17.0005
R1592 VSS.n1643 VSS.n1642 17.0005
R1593 VSS.n1642 VSS.n1641 17.0005
R1594 VSS.n1639 VSS.n1638 17.0005
R1595 VSS.n1638 VSS.n1637 17.0005
R1596 VSS.n1635 VSS.n1634 17.0005
R1597 VSS.n1634 VSS.n1633 17.0005
R1598 VSS.n1631 VSS.n1630 17.0005
R1599 VSS.n1630 VSS.n1629 17.0005
R1600 VSS.n1627 VSS.n1626 17.0005
R1601 VSS.n1626 VSS.n1625 17.0005
R1602 VSS.n1623 VSS.n1622 17.0005
R1603 VSS.n1622 VSS.n1621 17.0005
R1604 VSS.n1619 VSS.n1618 17.0005
R1605 VSS.n1618 VSS.n1617 17.0005
R1606 VSS.n1615 VSS.n1614 17.0005
R1607 VSS.n1614 VSS.n1613 17.0005
R1608 VSS.n1611 VSS.n1610 17.0005
R1609 VSS.n1610 VSS.n609 17.0005
R1610 VSS.n2887 VSS.n2886 17.0005
R1611 VSS.n2886 VSS.n2885 17.0005
R1612 VSS.n1177 VSS.n613 17.0005
R1613 VSS.n1178 VSS.n1177 17.0005
R1614 VSS.n1181 VSS.n1180 17.0005
R1615 VSS.n1182 VSS.n1181 17.0005
R1616 VSS.n1188 VSS.n1187 17.0005
R1617 VSS.n1189 VSS.n1188 17.0005
R1618 VSS.n1195 VSS.n1194 17.0005
R1619 VSS.n1196 VSS.n1195 17.0005
R1620 VSS.n1202 VSS.n1201 17.0005
R1621 VSS.n1203 VSS.n1202 17.0005
R1622 VSS.n1209 VSS.n1208 17.0005
R1623 VSS.n1210 VSS.n1209 17.0005
R1624 VSS.n1216 VSS.n1215 17.0005
R1625 VSS.n1217 VSS.n1216 17.0005
R1626 VSS.n1239 VSS.n1238 17.0005
R1627 VSS.n1240 VSS.n1239 17.0005
R1628 VSS.n1241 VSS.n1240 17.0005
R1629 VSS.n1242 VSS.n1241 17.0005
R1630 VSS.n1605 VSS.n1257 17.0005
R1631 VSS.n1605 VSS.n1604 17.0005
R1632 VSS.n670 VSS.n646 17.0005
R1633 VSS.n646 VSS.n615 17.0005
R1634 VSS.n2880 VSS.n646 17.0005
R1635 VSS.n673 VSS.n646 17.0005
R1636 VSS.n668 VSS.n646 17.0005
R1637 VSS.n674 VSS.n646 17.0005
R1638 VSS.n667 VSS.n646 17.0005
R1639 VSS.n675 VSS.n646 17.0005
R1640 VSS.n666 VSS.n646 17.0005
R1641 VSS.n676 VSS.n646 17.0005
R1642 VSS.n665 VSS.n646 17.0005
R1643 VSS.n677 VSS.n646 17.0005
R1644 VSS.n664 VSS.n646 17.0005
R1645 VSS.n678 VSS.n646 17.0005
R1646 VSS.n663 VSS.n646 17.0005
R1647 VSS.n679 VSS.n646 17.0005
R1648 VSS.n662 VSS.n646 17.0005
R1649 VSS.n682 VSS.n646 17.0005
R1650 VSS.n661 VSS.n646 17.0005
R1651 VSS.n684 VSS.n646 17.0005
R1652 VSS.n660 VSS.n646 17.0005
R1653 VSS.n686 VSS.n646 17.0005
R1654 VSS.n659 VSS.n646 17.0005
R1655 VSS.n689 VSS.n646 17.0005
R1656 VSS.n658 VSS.n646 17.0005
R1657 VSS.n691 VSS.n646 17.0005
R1658 VSS.n657 VSS.n646 17.0005
R1659 VSS.n695 VSS.n646 17.0005
R1660 VSS.n656 VSS.n646 17.0005
R1661 VSS.n697 VSS.n646 17.0005
R1662 VSS.n655 VSS.n646 17.0005
R1663 VSS.n700 VSS.n646 17.0005
R1664 VSS.n654 VSS.n646 17.0005
R1665 VSS.n702 VSS.n646 17.0005
R1666 VSS.n653 VSS.n646 17.0005
R1667 VSS.n705 VSS.n646 17.0005
R1668 VSS.n652 VSS.n646 17.0005
R1669 VSS.n1901 VSS.n1834 17.0005
R1670 VSS.n1901 VSS.n1855 17.0005
R1671 VSS.n1901 VSS.n1836 17.0005
R1672 VSS.n1901 VSS.n1837 17.0005
R1673 VSS.n1901 VSS.n1853 17.0005
R1674 VSS.n1901 VSS.n1850 17.0005
R1675 VSS.n1901 VSS.n1838 17.0005
R1676 VSS.n1901 VSS.n1849 17.0005
R1677 VSS.n1901 VSS.n1839 17.0005
R1678 VSS.n1901 VSS.n1848 17.0005
R1679 VSS.n1901 VSS.n1840 17.0005
R1680 VSS.n1901 VSS.n1847 17.0005
R1681 VSS.n1901 VSS.n1859 17.0005
R1682 VSS.n1901 VSS.n1846 17.0005
R1683 VSS.n1901 VSS.n1845 17.0005
R1684 VSS.n1901 VSS.n1842 17.0005
R1685 VSS.n1901 VSS.n1844 17.0005
R1686 VSS.n1901 VSS.n1843 17.0005
R1687 VSS.n1901 VSS.n1813 17.0005
R1688 VSS.n2331 VSS.n2095 17.0005
R1689 VSS.n2404 VSS.n647 17.0005
R1690 VSS.n2835 VSS.n647 17.0005
R1691 VSS.n2513 VSS.n647 17.0005
R1692 VSS.n2511 VSS.n647 17.0005
R1693 VSS.n1905 VSS.n1813 17.0005
R1694 VSS.n1905 VSS.n1843 17.0005
R1695 VSS.n1905 VSS.n1844 17.0005
R1696 VSS.n1905 VSS.n1842 17.0005
R1697 VSS.n1905 VSS.n1845 17.0005
R1698 VSS.n1905 VSS.n1846 17.0005
R1699 VSS.n1905 VSS.n1847 17.0005
R1700 VSS.n1905 VSS.n1840 17.0005
R1701 VSS.n1905 VSS.n1848 17.0005
R1702 VSS.n1905 VSS.n1839 17.0005
R1703 VSS.n1905 VSS.n1849 17.0005
R1704 VSS.n1905 VSS.n1838 17.0005
R1705 VSS.n1905 VSS.n1850 17.0005
R1706 VSS.n1905 VSS.n1853 17.0005
R1707 VSS.n1905 VSS.n1837 17.0005
R1708 VSS.n1905 VSS.n1854 17.0005
R1709 VSS.n1905 VSS.n1836 17.0005
R1710 VSS.n1905 VSS.n1855 17.0005
R1711 VSS.n1905 VSS.n1834 17.0005
R1712 VSS.n1749 VSS.t122 17.0005
R1713 VSS.n1748 VSS.t122 17.0005
R1714 VSS.n1747 VSS.t122 17.0005
R1715 VSS.n1746 VSS.t122 17.0005
R1716 VSS.n1745 VSS.t122 17.0005
R1717 VSS.n1744 VSS.t122 17.0005
R1718 VSS.n1743 VSS.t122 17.0005
R1719 VSS.n1742 VSS.t122 17.0005
R1720 VSS.n1741 VSS.t122 17.0005
R1721 VSS.n1740 VSS.t122 17.0005
R1722 VSS.n1739 VSS.t122 17.0005
R1723 VSS.n1738 VSS.t122 17.0005
R1724 VSS.n1737 VSS.t122 17.0005
R1725 VSS.n1736 VSS.t122 17.0005
R1726 VSS.n1735 VSS.t122 17.0005
R1727 VSS.n1734 VSS.t122 17.0005
R1728 VSS.n1733 VSS.t122 17.0005
R1729 VSS.n1732 VSS.t122 17.0005
R1730 VSS.n1731 VSS.t122 17.0005
R1731 VSS.n1730 VSS.t122 17.0005
R1732 VSS.n1729 VSS.t122 17.0005
R1733 VSS.n1728 VSS.t122 17.0005
R1734 VSS.n1727 VSS.t122 17.0005
R1735 VSS.n1726 VSS.t122 17.0005
R1736 VSS.n1725 VSS.t122 17.0005
R1737 VSS.n1724 VSS.t122 17.0005
R1738 VSS.n1723 VSS.t122 17.0005
R1739 VSS.n1722 VSS.t122 17.0005
R1740 VSS.n1750 VSS.t122 17.0005
R1741 VSS.n1971 VSS.t125 17.0005
R1742 VSS.n1781 VSS.t125 17.0005
R1743 VSS.n1970 VSS.t125 17.0005
R1744 VSS.n1782 VSS.t125 17.0005
R1745 VSS.n1969 VSS.t125 17.0005
R1746 VSS.n1783 VSS.t125 17.0005
R1747 VSS.n1968 VSS.t125 17.0005
R1748 VSS.n1784 VSS.t125 17.0005
R1749 VSS.n1967 VSS.t125 17.0005
R1750 VSS.n1948 VSS.t125 17.0005
R1751 VSS.n1966 VSS.t125 17.0005
R1752 VSS.n1949 VSS.t125 17.0005
R1753 VSS.n1965 VSS.t125 17.0005
R1754 VSS.n1950 VSS.t125 17.0005
R1755 VSS.n1964 VSS.t125 17.0005
R1756 VSS.n1951 VSS.t125 17.0005
R1757 VSS.n1963 VSS.t125 17.0005
R1758 VSS.n1952 VSS.t125 17.0005
R1759 VSS.n1962 VSS.t125 17.0005
R1760 VSS.n1953 VSS.t125 17.0005
R1761 VSS.n1961 VSS.t125 17.0005
R1762 VSS.n1954 VSS.t125 17.0005
R1763 VSS.n1960 VSS.t125 17.0005
R1764 VSS.n1955 VSS.t125 17.0005
R1765 VSS.n1959 VSS.t125 17.0005
R1766 VSS.n1956 VSS.t125 17.0005
R1767 VSS.n1958 VSS.t125 17.0005
R1768 VSS.n1957 VSS.t125 17.0005
R1769 VSS.n1972 VSS.t125 17.0005
R1770 VSS.t123 VSS.n1749 17.0005
R1771 VSS.t123 VSS.n1748 17.0005
R1772 VSS.t123 VSS.n1747 17.0005
R1773 VSS.t123 VSS.n1746 17.0005
R1774 VSS.t123 VSS.n1745 17.0005
R1775 VSS.t123 VSS.n1744 17.0005
R1776 VSS.t123 VSS.n1743 17.0005
R1777 VSS.t123 VSS.n1742 17.0005
R1778 VSS.t123 VSS.n1741 17.0005
R1779 VSS.t123 VSS.n1740 17.0005
R1780 VSS.t123 VSS.n1739 17.0005
R1781 VSS.t123 VSS.n1738 17.0005
R1782 VSS.t123 VSS.n1737 17.0005
R1783 VSS.t123 VSS.n1736 17.0005
R1784 VSS.t123 VSS.n1735 17.0005
R1785 VSS.t123 VSS.n1734 17.0005
R1786 VSS.t123 VSS.n1733 17.0005
R1787 VSS.t123 VSS.n1732 17.0005
R1788 VSS.t123 VSS.n1731 17.0005
R1789 VSS.t123 VSS.n1730 17.0005
R1790 VSS.t123 VSS.n1729 17.0005
R1791 VSS.t123 VSS.n1728 17.0005
R1792 VSS.t123 VSS.n1727 17.0005
R1793 VSS.t123 VSS.n1726 17.0005
R1794 VSS.t123 VSS.n1725 17.0005
R1795 VSS.t123 VSS.n1724 17.0005
R1796 VSS.t123 VSS.n1723 17.0005
R1797 VSS.t123 VSS.n1722 17.0005
R1798 VSS.n1750 VSS.t123 17.0005
R1799 VSS.t126 VSS.n1971 17.0005
R1800 VSS.t126 VSS.n1781 17.0005
R1801 VSS.t126 VSS.n1970 17.0005
R1802 VSS.t126 VSS.n1782 17.0005
R1803 VSS.t126 VSS.n1969 17.0005
R1804 VSS.t126 VSS.n1783 17.0005
R1805 VSS.t126 VSS.n1968 17.0005
R1806 VSS.t126 VSS.n1784 17.0005
R1807 VSS.t126 VSS.n1967 17.0005
R1808 VSS.t126 VSS.n1948 17.0005
R1809 VSS.t126 VSS.n1966 17.0005
R1810 VSS.t126 VSS.n1949 17.0005
R1811 VSS.t126 VSS.n1965 17.0005
R1812 VSS.t126 VSS.n1950 17.0005
R1813 VSS.t126 VSS.n1964 17.0005
R1814 VSS.t126 VSS.n1951 17.0005
R1815 VSS.t126 VSS.n1963 17.0005
R1816 VSS.t126 VSS.n1952 17.0005
R1817 VSS.t126 VSS.n1962 17.0005
R1818 VSS.t126 VSS.n1953 17.0005
R1819 VSS.t126 VSS.n1961 17.0005
R1820 VSS.t126 VSS.n1954 17.0005
R1821 VSS.t126 VSS.n1960 17.0005
R1822 VSS.t126 VSS.n1955 17.0005
R1823 VSS.t126 VSS.n1959 17.0005
R1824 VSS.t126 VSS.n1956 17.0005
R1825 VSS.t126 VSS.n1958 17.0005
R1826 VSS.t126 VSS.n1957 17.0005
R1827 VSS.n1972 VSS.t126 17.0005
R1828 VSS.n2872 VSS.n1694 17.0005
R1829 VSS.n2872 VSS.n1695 17.0005
R1830 VSS.n2872 VSS.n1696 17.0005
R1831 VSS.n2872 VSS.n1697 17.0005
R1832 VSS.n2872 VSS.n1698 17.0005
R1833 VSS.n2872 VSS.n1699 17.0005
R1834 VSS.n2872 VSS.n1700 17.0005
R1835 VSS.n2872 VSS.n1701 17.0005
R1836 VSS.n2872 VSS.n1702 17.0005
R1837 VSS.n2872 VSS.n1703 17.0005
R1838 VSS.n2872 VSS.n1704 17.0005
R1839 VSS.n2872 VSS.n1705 17.0005
R1840 VSS.n2872 VSS.n1706 17.0005
R1841 VSS.n2872 VSS.n1707 17.0005
R1842 VSS.n2872 VSS.n1708 17.0005
R1843 VSS.n2872 VSS.n1709 17.0005
R1844 VSS.n2872 VSS.n1710 17.0005
R1845 VSS.n2872 VSS.n1711 17.0005
R1846 VSS.n2872 VSS.n1712 17.0005
R1847 VSS.n2872 VSS.n1713 17.0005
R1848 VSS.n2872 VSS.n1714 17.0005
R1849 VSS.n2872 VSS.n1715 17.0005
R1850 VSS.n2872 VSS.n1716 17.0005
R1851 VSS.n2872 VSS.n1717 17.0005
R1852 VSS.n2872 VSS.n1718 17.0005
R1853 VSS.n2872 VSS.n1719 17.0005
R1854 VSS.n2872 VSS.n1720 17.0005
R1855 VSS.n2872 VSS.n1721 17.0005
R1856 VSS.n2872 VSS.n1753 17.0005
R1857 VSS.n2872 VSS.n1754 17.0005
R1858 VSS.n2872 VSS.n1755 17.0005
R1859 VSS.n2872 VSS.n1756 17.0005
R1860 VSS.n2872 VSS.n1757 17.0005
R1861 VSS.n2872 VSS.n1758 17.0005
R1862 VSS.n2872 VSS.n1759 17.0005
R1863 VSS.n2872 VSS.n1760 17.0005
R1864 VSS.n2872 VSS.n1761 17.0005
R1865 VSS.n2872 VSS.n1762 17.0005
R1866 VSS.n2872 VSS.n1763 17.0005
R1867 VSS.n2872 VSS.n1764 17.0005
R1868 VSS.n2872 VSS.n1765 17.0005
R1869 VSS.n2872 VSS.n1766 17.0005
R1870 VSS.n2872 VSS.n1767 17.0005
R1871 VSS.n2872 VSS.n1768 17.0005
R1872 VSS.n2872 VSS.n1769 17.0005
R1873 VSS.n2872 VSS.n1770 17.0005
R1874 VSS.n2872 VSS.n1771 17.0005
R1875 VSS.n2872 VSS.n1772 17.0005
R1876 VSS.n2872 VSS.n1773 17.0005
R1877 VSS.n2872 VSS.n1774 17.0005
R1878 VSS.n2872 VSS.n1775 17.0005
R1879 VSS.n2872 VSS.n1776 17.0005
R1880 VSS.n2872 VSS.n1777 17.0005
R1881 VSS.n2872 VSS.n1778 17.0005
R1882 VSS.n2872 VSS.n1779 17.0005
R1883 VSS.n2872 VSS.n1780 17.0005
R1884 VSS.n2043 VSS.t88 17.0005
R1885 VSS.n2044 VSS.t88 17.0005
R1886 VSS.n2045 VSS.t88 17.0005
R1887 VSS.n2046 VSS.t88 17.0005
R1888 VSS.n2047 VSS.t88 17.0005
R1889 VSS.n2048 VSS.t88 17.0005
R1890 VSS.n2049 VSS.t88 17.0005
R1891 VSS.n2050 VSS.t88 17.0005
R1892 VSS.n2051 VSS.t88 17.0005
R1893 VSS.n2052 VSS.t88 17.0005
R1894 VSS.n2053 VSS.t88 17.0005
R1895 VSS.n2054 VSS.t88 17.0005
R1896 VSS.n2055 VSS.t88 17.0005
R1897 VSS.n2056 VSS.t88 17.0005
R1898 VSS.n2057 VSS.t88 17.0005
R1899 VSS.n2058 VSS.t88 17.0005
R1900 VSS.n2059 VSS.t88 17.0005
R1901 VSS.n2060 VSS.t88 17.0005
R1902 VSS.n2061 VSS.t88 17.0005
R1903 VSS.n2062 VSS.t88 17.0005
R1904 VSS.n2063 VSS.t88 17.0005
R1905 VSS.n2064 VSS.t88 17.0005
R1906 VSS.n2065 VSS.t88 17.0005
R1907 VSS.n2066 VSS.t88 17.0005
R1908 VSS.n2067 VSS.t88 17.0005
R1909 VSS.n2068 VSS.t88 17.0005
R1910 VSS.n2069 VSS.t88 17.0005
R1911 VSS.n2070 VSS.t88 17.0005
R1912 VSS.n2071 VSS.t88 17.0005
R1913 VSS.n2336 VSS.t82 17.0005
R1914 VSS.n2337 VSS.t82 17.0005
R1915 VSS.n2338 VSS.t82 17.0005
R1916 VSS.n2339 VSS.t82 17.0005
R1917 VSS.n2340 VSS.t82 17.0005
R1918 VSS.n2868 VSS.t82 17.0005
R1919 VSS.t81 VSS.n2868 17.0005
R1920 VSS.t81 VSS.n2340 17.0005
R1921 VSS.t81 VSS.n2339 17.0005
R1922 VSS.t81 VSS.n2338 17.0005
R1923 VSS.t81 VSS.n2337 17.0005
R1924 VSS.t81 VSS.n2336 17.0005
R1925 VSS.n2071 VSS.t87 17.0005
R1926 VSS.t87 VSS.n2070 17.0005
R1927 VSS.t87 VSS.n2069 17.0005
R1928 VSS.t87 VSS.n2068 17.0005
R1929 VSS.t87 VSS.n2067 17.0005
R1930 VSS.t87 VSS.n2066 17.0005
R1931 VSS.t87 VSS.n2065 17.0005
R1932 VSS.t87 VSS.n2064 17.0005
R1933 VSS.t87 VSS.n2063 17.0005
R1934 VSS.t87 VSS.n2062 17.0005
R1935 VSS.t87 VSS.n2061 17.0005
R1936 VSS.t87 VSS.n2060 17.0005
R1937 VSS.t87 VSS.n2059 17.0005
R1938 VSS.t87 VSS.n2058 17.0005
R1939 VSS.t87 VSS.n2057 17.0005
R1940 VSS.t87 VSS.n2056 17.0005
R1941 VSS.t87 VSS.n2055 17.0005
R1942 VSS.t87 VSS.n2054 17.0005
R1943 VSS.t87 VSS.n2053 17.0005
R1944 VSS.t87 VSS.n2052 17.0005
R1945 VSS.t87 VSS.n2051 17.0005
R1946 VSS.t87 VSS.n2050 17.0005
R1947 VSS.t87 VSS.n2049 17.0005
R1948 VSS.t87 VSS.n2048 17.0005
R1949 VSS.t87 VSS.n2047 17.0005
R1950 VSS.t87 VSS.n2046 17.0005
R1951 VSS.t87 VSS.n2045 17.0005
R1952 VSS.t87 VSS.n2044 17.0005
R1953 VSS.t87 VSS.n2043 17.0005
R1954 VSS.n2872 VSS.n2083 17.0005
R1955 VSS.n2872 VSS.n2082 17.0005
R1956 VSS.n2872 VSS.n2081 17.0005
R1957 VSS.n2872 VSS.n2080 17.0005
R1958 VSS.n2872 VSS.n2079 17.0005
R1959 VSS.n2872 VSS.n2042 17.0005
R1960 VSS.n2872 VSS.n2041 17.0005
R1961 VSS.n2872 VSS.n2040 17.0005
R1962 VSS.n2872 VSS.n2039 17.0005
R1963 VSS.n2872 VSS.n2038 17.0005
R1964 VSS.n2872 VSS.n2037 17.0005
R1965 VSS.n2872 VSS.n2036 17.0005
R1966 VSS.n2872 VSS.n2035 17.0005
R1967 VSS.n2872 VSS.n2034 17.0005
R1968 VSS.n2872 VSS.n2033 17.0005
R1969 VSS.n2872 VSS.n2032 17.0005
R1970 VSS.n2872 VSS.n2031 17.0005
R1971 VSS.n2872 VSS.n2030 17.0005
R1972 VSS.n2872 VSS.n2029 17.0005
R1973 VSS.n2872 VSS.n2028 17.0005
R1974 VSS.n2872 VSS.n2027 17.0005
R1975 VSS.n2872 VSS.n2026 17.0005
R1976 VSS.n2872 VSS.n2025 17.0005
R1977 VSS.n2872 VSS.n2024 17.0005
R1978 VSS.n2872 VSS.n2023 17.0005
R1979 VSS.n2872 VSS.n2022 17.0005
R1980 VSS.n2872 VSS.n2021 17.0005
R1981 VSS.n2872 VSS.n2020 17.0005
R1982 VSS.n2872 VSS.n2019 17.0005
R1983 VSS.n2872 VSS.n2018 17.0005
R1984 VSS.n2872 VSS.n2017 17.0005
R1985 VSS.n2872 VSS.n2016 17.0005
R1986 VSS.n2872 VSS.n2015 17.0005
R1987 VSS.n2341 VSS.t82 17.0005
R1988 VSS.n2867 VSS.t82 17.0005
R1989 VSS.n2342 VSS.t82 17.0005
R1990 VSS.n2866 VSS.t82 17.0005
R1991 VSS.n2343 VSS.t82 17.0005
R1992 VSS.n2863 VSS.t82 17.0005
R1993 VSS.n2344 VSS.t82 17.0005
R1994 VSS.n2859 VSS.t82 17.0005
R1995 VSS.n2345 VSS.t82 17.0005
R1996 VSS.n2855 VSS.t82 17.0005
R1997 VSS.n2346 VSS.t82 17.0005
R1998 VSS.n2851 VSS.t82 17.0005
R1999 VSS.n2347 VSS.t82 17.0005
R2000 VSS.n2847 VSS.t82 17.0005
R2001 VSS.n2348 VSS.t82 17.0005
R2002 VSS.n2366 VSS.t82 17.0005
R2003 VSS.n2349 VSS.t82 17.0005
R2004 VSS.n2362 VSS.t82 17.0005
R2005 VSS.n2350 VSS.t82 17.0005
R2006 VSS.n2358 VSS.t82 17.0005
R2007 VSS.n2351 VSS.t82 17.0005
R2008 VSS.n2354 VSS.t82 17.0005
R2009 VSS.n2869 VSS.t82 17.0005
R2010 VSS.n2869 VSS.t81 17.0005
R2011 VSS.t81 VSS.n2354 17.0005
R2012 VSS.t81 VSS.n2351 17.0005
R2013 VSS.t81 VSS.n2358 17.0005
R2014 VSS.t81 VSS.n2350 17.0005
R2015 VSS.t81 VSS.n2362 17.0005
R2016 VSS.t81 VSS.n2349 17.0005
R2017 VSS.t81 VSS.n2366 17.0005
R2018 VSS.t81 VSS.n2348 17.0005
R2019 VSS.t81 VSS.n2847 17.0005
R2020 VSS.t81 VSS.n2347 17.0005
R2021 VSS.t81 VSS.n2851 17.0005
R2022 VSS.t81 VSS.n2346 17.0005
R2023 VSS.t81 VSS.n2855 17.0005
R2024 VSS.t81 VSS.n2345 17.0005
R2025 VSS.t81 VSS.n2859 17.0005
R2026 VSS.t81 VSS.n2344 17.0005
R2027 VSS.t81 VSS.n2863 17.0005
R2028 VSS.t81 VSS.n2343 17.0005
R2029 VSS.t81 VSS.n2866 17.0005
R2030 VSS.t81 VSS.n2342 17.0005
R2031 VSS.t81 VSS.n2867 17.0005
R2032 VSS.t81 VSS.n2341 17.0005
R2033 VSS.n2352 VSS.n2335 17.0005
R2034 VSS.n2353 VSS.n2352 17.0005
R2035 VSS.n2357 VSS.n2356 17.0005
R2036 VSS.n2356 VSS.n2355 17.0005
R2037 VSS.n2361 VSS.n2360 17.0005
R2038 VSS.n2360 VSS.n2359 17.0005
R2039 VSS.n2365 VSS.n2364 17.0005
R2040 VSS.n2364 VSS.n2363 17.0005
R2041 VSS.n2846 VSS.n2845 17.0005
R2042 VSS.n2845 VSS.n2844 17.0005
R2043 VSS.n2850 VSS.n2849 17.0005
R2044 VSS.n2849 VSS.n2848 17.0005
R2045 VSS.n2854 VSS.n2853 17.0005
R2046 VSS.n2853 VSS.n2852 17.0005
R2047 VSS.n2858 VSS.n2857 17.0005
R2048 VSS.n2857 VSS.n2856 17.0005
R2049 VSS.n2862 VSS.n2861 17.0005
R2050 VSS.n2861 VSS.n2860 17.0005
R2051 VSS.n2865 VSS.n1690 17.0005
R2052 VSS.n2864 VSS.n1690 17.0005
R2053 VSS.n2872 VSS.n2010 17.0005
R2054 VSS.n2872 VSS.n2009 17.0005
R2055 VSS.n2872 VSS.n2084 17.0005
R2056 VSS.n2378 VSS.n2377 17.0005
R2057 VSS.n2379 VSS.n2378 17.0005
R2058 VSS.n2397 VSS.n2396 17.0005
R2059 VSS.n2398 VSS.n2397 17.0005
R2060 VSS.n705 VSS.n6 17.0005
R2061 VSS.n653 VSS.n6 17.0005
R2062 VSS.n702 VSS.n6 17.0005
R2063 VSS.n654 VSS.n6 17.0005
R2064 VSS.n700 VSS.n6 17.0005
R2065 VSS.n655 VSS.n6 17.0005
R2066 VSS.n682 VSS.n6 17.0005
R2067 VSS.n662 VSS.n6 17.0005
R2068 VSS.n679 VSS.n6 17.0005
R2069 VSS.n663 VSS.n6 17.0005
R2070 VSS.n678 VSS.n6 17.0005
R2071 VSS.n664 VSS.n6 17.0005
R2072 VSS.n677 VSS.n6 17.0005
R2073 VSS.n665 VSS.n6 17.0005
R2074 VSS.n676 VSS.n6 17.0005
R2075 VSS.n666 VSS.n6 17.0005
R2076 VSS.n675 VSS.n6 17.0005
R2077 VSS.n667 VSS.n6 17.0005
R2078 VSS.n674 VSS.n6 17.0005
R2079 VSS.n668 VSS.n6 17.0005
R2080 VSS.n673 VSS.n6 17.0005
R2081 VSS.n2880 VSS.n6 17.0005
R2082 VSS.n615 VSS.n6 17.0005
R2083 VSS.n670 VSS.n6 17.0005
R2084 VSS.n2934 VSS.n2933 17.0005
R2085 VSS.n2933 VSS.n35 17.0005
R2086 VSS.n652 VSS.n6 17.0005
R2087 VSS.n697 VSS.n6 17.0005
R2088 VSS.n656 VSS.n6 17.0005
R2089 VSS.n695 VSS.n6 17.0005
R2090 VSS.n657 VSS.n6 17.0005
R2091 VSS.n691 VSS.n6 17.0005
R2092 VSS.n658 VSS.n6 17.0005
R2093 VSS.n689 VSS.n6 17.0005
R2094 VSS.n659 VSS.n6 17.0005
R2095 VSS.n686 VSS.n6 17.0005
R2096 VSS.n660 VSS.n6 17.0005
R2097 VSS.n684 VSS.n6 17.0005
R2098 VSS.n661 VSS.n6 17.0005
R2099 VSS.t8 VSS.n453 16.7136
R2100 VSS.n931 VSS.n451 16.7136
R2101 VSS.n935 VSS.n934 16.7136
R2102 VSS.n1857 VSS.n1791 16.5808
R2103 VSS.n2087 VSS.n2013 16.1322
R2104 VSS.n2333 VSS.n2332 16.1322
R2105 VSS.n2260 VSS.n2086 16.1322
R2106 VSS.n2259 VSS.n2011 16.1322
R2107 VSS.n2258 VSS.n2085 16.1322
R2108 VSS.n2257 VSS.t112 16.1322
R2109 VSS.n2256 VSS.n2008 16.1322
R2110 VSS.n2255 VSS.n2007 16.1322
R2111 VSS.n2253 VSS.n2005 16.1322
R2112 VSS.n2252 VSS.n2004 16.1322
R2113 VSS.n2251 VSS.n2003 16.1322
R2114 VSS.n2250 VSS.n2002 16.1322
R2115 VSS.n2249 VSS.n2001 16.1322
R2116 VSS.n2246 VSS.n1998 16.1322
R2117 VSS.n2182 VSS.n1997 16.1322
R2118 VSS.n2181 VSS.n1995 16.1322
R2119 VSS.n1903 VSS.n1792 15.8877
R2120 VSS.n1834 VSS.n1786 15.8877
R2121 VSS.n1855 VSS.n1793 15.8877
R2122 VSS.n1836 VSS.n1794 15.8877
R2123 VSS.n1837 VSS.n1796 15.8877
R2124 VSS.n1853 VSS.n1797 15.8877
R2125 VSS.n1839 VSS.n1801 15.8877
R2126 VSS.n1851 VSS.t42 15.4955
R2127 VSS.n473 VSS.n454 15.4795
R2128 VSS.n1590 VSS.t166 15.4617
R2129 VSS.t72 VSS.n665 15.3989
R2130 VSS.n1088 VSS.t5 15.3601
R2131 VSS.n293 VSS.t68 15.0423
R2132 VSS.n333 VSS.t138 15.0423
R2133 VSS.n925 VSS.t165 15.0112
R2134 VSS.n989 VSS.t167 15.0107
R2135 VSS.n2780 VSS.t131 15.0005
R2136 VSS.n2668 VSS.t63 15.0005
R2137 VSS.t63 VSS.n2667 15.0005
R2138 VSS.n2608 VSS.t45 15.0005
R2139 VSS.t45 VSS.n2607 15.0005
R2140 VSS.n1601 VSS.t170 15.0005
R2141 VSS.n1599 VSS.t169 15.0005
R2142 VSS.n300 VSS.t67 15.0005
R2143 VSS.t67 VSS.n297 15.0005
R2144 VSS.t67 VSS.n296 15.0005
R2145 VSS.t67 VSS.n299 15.0005
R2146 VSS.n277 VSS.t107 15.0005
R2147 VSS.t107 VSS.n275 15.0005
R2148 VSS.t107 VSS.n274 15.0005
R2149 VSS.t107 VSS.n276 15.0005
R2150 VSS.t52 VSS.n1386 15.0005
R2151 VSS.t52 VSS.n1387 15.0005
R2152 VSS.n1390 VSS.t52 15.0005
R2153 VSS.t52 VSS.n1389 15.0005
R2154 VSS.t137 VSS.n1369 15.0005
R2155 VSS.t137 VSS.n1370 15.0005
R2156 VSS.n1373 VSS.t137 15.0005
R2157 VSS.t137 VSS.n1372 15.0005
R2158 VSS.t43 VSS.n1399 15.0005
R2159 VSS.t43 VSS.n1398 15.0005
R2160 VSS.t43 VSS.n1397 15.0005
R2161 VSS.t43 VSS.n1396 15.0005
R2162 VSS.t43 VSS.n1384 15.0005
R2163 VSS.t43 VSS.n1383 15.0005
R2164 VSS.t43 VSS.n1382 15.0005
R2165 VSS.t43 VSS.n1381 15.0005
R2166 VSS.t43 VSS.n1380 15.0005
R2167 VSS.t43 VSS.n1379 15.0005
R2168 VSS.t43 VSS.n1378 15.0005
R2169 VSS.t43 VSS.n1377 15.0005
R2170 VSS.t43 VSS.n1376 15.0005
R2171 VSS.t43 VSS.n1367 15.0005
R2172 VSS.t43 VSS.n1366 15.0005
R2173 VSS.t43 VSS.n1365 15.0005
R2174 VSS.t43 VSS.n1364 15.0005
R2175 VSS.t43 VSS.n1363 15.0005
R2176 VSS.t43 VSS.n1362 15.0005
R2177 VSS.t43 VSS.n1360 15.0005
R2178 VSS.t43 VSS.n1359 15.0005
R2179 VSS.t43 VSS.n1358 15.0005
R2180 VSS.t43 VSS.n1331 15.0005
R2181 VSS.t43 VSS.n1330 15.0005
R2182 VSS.t43 VSS.n1328 15.0005
R2183 VSS.t43 VSS.n1327 15.0005
R2184 VSS.t43 VSS.n1326 15.0005
R2185 VSS.t43 VSS.n1325 15.0005
R2186 VSS.t43 VSS.n1324 15.0005
R2187 VSS.t43 VSS.n1323 15.0005
R2188 VSS.t43 VSS.n1322 15.0005
R2189 VSS.t43 VSS.n1320 15.0005
R2190 VSS.t43 VSS.n1319 15.0005
R2191 VSS.t43 VSS.n1318 15.0005
R2192 VSS.t43 VSS.n1317 15.0005
R2193 VSS.t43 VSS.n1316 15.0005
R2194 VSS.t43 VSS.n1315 15.0005
R2195 VSS.t43 VSS.n1314 15.0005
R2196 VSS.t43 VSS.n1313 15.0005
R2197 VSS.t43 VSS.n1312 15.0005
R2198 VSS.t43 VSS.n1308 15.0005
R2199 VSS.t43 VSS.n1307 15.0005
R2200 VSS.t43 VSS.n1306 15.0005
R2201 VSS.t43 VSS.n1305 15.0005
R2202 VSS.t43 VSS.n1304 15.0005
R2203 VSS.t43 VSS.n1301 15.0005
R2204 VSS.t43 VSS.n1300 15.0005
R2205 VSS.t43 VSS.n1295 15.0005
R2206 VSS.t43 VSS.n1401 15.0005
R2207 VSS.t43 VSS.n1469 15.0005
R2208 VSS.t43 VSS.n1472 15.0005
R2209 VSS.t43 VSS.n1474 15.0005
R2210 VSS.t43 VSS.n1475 15.0005
R2211 VSS.t43 VSS.n1477 15.0005
R2212 VSS.t43 VSS.n1479 15.0005
R2213 VSS.t43 VSS.n1481 15.0005
R2214 VSS.t43 VSS.n1483 15.0005
R2215 VSS.t43 VSS.n1485 15.0005
R2216 VSS.t43 VSS.n1487 15.0005
R2217 VSS.t43 VSS.n1489 15.0005
R2218 VSS.t43 VSS.n1491 15.0005
R2219 VSS.t43 VSS.n1493 15.0005
R2220 VSS.t43 VSS.n1495 15.0005
R2221 VSS.t43 VSS.n1497 15.0005
R2222 VSS.n1568 VSS.t43 15.0005
R2223 VSS.t43 VSS.n1292 15.0005
R2224 VSS.t43 VSS.n1499 15.0005
R2225 VSS.t43 VSS.n1502 15.0005
R2226 VSS.t43 VSS.n1504 15.0005
R2227 VSS.t43 VSS.n1506 15.0005
R2228 VSS.t43 VSS.n1508 15.0005
R2229 VSS.t43 VSS.n1510 15.0005
R2230 VSS.t43 VSS.n1514 15.0005
R2231 VSS.t43 VSS.n1516 15.0005
R2232 VSS.t43 VSS.n1518 15.0005
R2233 VSS.t43 VSS.n1520 15.0005
R2234 VSS.t43 VSS.n1522 15.0005
R2235 VSS.t43 VSS.n1524 15.0005
R2236 VSS.t43 VSS.n1527 15.0005
R2237 VSS.t43 VSS.n1529 15.0005
R2238 VSS.t43 VSS.n1531 15.0005
R2239 VSS.t43 VSS.n1533 15.0005
R2240 VSS.t43 VSS.n1535 15.0005
R2241 VSS.t43 VSS.n1537 15.0005
R2242 VSS.t43 VSS.n1539 15.0005
R2243 VSS.t43 VSS.n1541 15.0005
R2244 VSS.t43 VSS.n1543 15.0005
R2245 VSS.t43 VSS.n1545 15.0005
R2246 VSS.t43 VSS.n1547 15.0005
R2247 VSS.t43 VSS.n1549 15.0005
R2248 VSS.t43 VSS.n1551 15.0005
R2249 VSS.t43 VSS.n1553 15.0005
R2250 VSS.t43 VSS.n1554 15.0005
R2251 VSS.t43 VSS.n1556 15.0005
R2252 VSS.t43 VSS.n1294 15.0005
R2253 VSS.t43 VSS.n1567 15.0005
R2254 VSS.n1593 VSS.t27 15.0005
R2255 VSS.n1590 VSS.t26 15.0005
R2256 VSS.n1597 VSS.t7 15.0005
R2257 VSS.n1595 VSS.t6 15.0005
R2258 VSS.n1258 VSS.t168 15.0005
R2259 VSS.t71 VSS.n1137 15.0005
R2260 VSS.t71 VSS.n1138 15.0005
R2261 VSS.t71 VSS.n1136 15.0005
R2262 VSS.t71 VSS.n1139 15.0005
R2263 VSS.t71 VSS.n1155 15.0005
R2264 VSS.n1156 VSS.t71 15.0005
R2265 VSS.t71 VSS.n1133 15.0005
R2266 VSS.n471 VSS.t164 15.0005
R2267 VSS.n1648 VSS.t3 15.0005
R2268 VSS.n781 VSS.t2 15.0005
R2269 VSS.t1 VSS.n2875 14.2915
R2270 VSS.n1838 VSS.t41 14.1768
R2271 VSS.n1787 VSS.n69 13.8099
R2272 VSS.n2088 VSS.n1691 13.5181
R2273 VSS.n1789 VSS.t184 13.4339
R2274 VSS.n262 VSS.t92 13.371
R2275 VSS.n357 VSS.t56 13.371
R2276 VSS.n481 VSS.n68 13.371
R2277 VSS.n2745 VSS.n2744 13.2089
R2278 VSS.n2931 VSS.n37 13.1724
R2279 VSS.n2748 VSS.n2747 13.0945
R2280 VSS.t0 VSS.n538 12.8142
R2281 VSS.t64 VSS.n2520 12.467
R2282 VSS.n1840 VSS.n1803 12.4659
R2283 VSS.n1847 VSS.n1804 12.4659
R2284 VSS.t185 VSS.n1807 12.4659
R2285 VSS.n1845 VSS.n1808 12.4659
R2286 VSS.n1843 VSS.n1811 12.4659
R2287 VSS.n1813 VSS.n1812 12.4659
R2288 VSS.n2881 VSS.n615 12.2215
R2289 VSS.n2181 VSS.n1994 12.2215
R2290 VSS.n1857 VSS.n1842 11.977
R2291 VSS.n1677 VSS.n1676 11.824
R2292 VSS.t185 VSS.n1850 11.7326
R2293 VSS.t8 VSS.n900 11.6997
R2294 VSS.n931 VSS.n453 11.6997
R2295 VSS.n934 VSS.n451 11.6997
R2296 VSS.n935 VSS.n588 11.6997
R2297 VSS.n2880 VSS.n645 11.4882
R2298 VSS.n1013 VSS.n673 11.4882
R2299 VSS.n1015 VSS.n668 11.4882
R2300 VSS.n1017 VSS.n674 11.4882
R2301 VSS.n1021 VSS.n675 11.4882
R2302 VSS.n1023 VSS.n666 11.4882
R2303 VSS.t185 VSS.n1800 11.4882
R2304 VSS.n2876 VSS.n691 11.1911
R2305 VSS.t174 VSS.t25 10.9994
R2306 VSS.t12 VSS.n667 10.7549
R2307 VSS.n2919 VSS.n449 10.4462
R2308 VSS.n2916 VSS.n2915 10.4462
R2309 VSS.n476 VSS.n470 10.4462
R2310 VSS.n477 VSS.n469 10.4462
R2311 VSS.n478 VSS.n467 10.4462
R2312 VSS.n479 VSS.n466 10.4462
R2313 VSS.n480 VSS.n465 10.4462
R2314 VSS.n481 VSS.n464 10.4462
R2315 VSS.n868 VSS.t128 10.2745
R2316 VSS.n1607 VSS.n661 10.2661
R2317 VSS.n684 VSS.n683 10.2661
R2318 VSS.n685 VSS.n660 10.2661
R2319 VSS.n2877 VSS.n686 10.2661
R2320 VSS.n687 VSS.n659 10.2661
R2321 VSS.n689 VSS.n688 10.2661
R2322 VSS.n690 VSS.n658 10.2661
R2323 VSS.n692 VSS.n657 10.2661
R2324 VSS.n696 VSS.n656 10.2661
R2325 VSS.t1 VSS.n697 10.2661
R2326 VSS.n698 VSS.n655 10.2661
R2327 VSS.n700 VSS.n699 10.2661
R2328 VSS.n701 VSS.n654 10.2661
R2329 VSS.n705 VSS.n703 10.2661
R2330 VSS.n704 VSS.n652 10.2661
R2331 VSS.n2878 VSS.n706 10.2661
R2332 VSS.n2261 VSS.t80 10.2661
R2333 VSS.n2254 VSS.t182 10.2661
R2334 VSS.n2247 VSS.t171 10.2661
R2335 VSS.n2925 VSS.n71 10.0284
R2336 VSS.n2924 VSS.n181 10.0284
R2337 VSS.n256 VSS.n180 10.0284
R2338 VSS.n257 VSS.n179 10.0284
R2339 VSS.n261 VSS.n176 10.0284
R2340 VSS.n262 VSS.n175 10.0284
R2341 VSS.n268 VSS.n172 10.0284
R2342 VSS.n269 VSS.t108 10.0284
R2343 VSS.n269 VSS.n171 10.0284
R2344 VSS.n272 VSS.n168 10.0284
R2345 VSS.n273 VSS.n167 10.0284
R2346 VSS.n280 VSS.n164 10.0284
R2347 VSS.n281 VSS.n163 10.0284
R2348 VSS.n287 VSS.n160 10.0284
R2349 VSS.n288 VSS.n159 10.0284
R2350 VSS.t32 VSS.n156 10.0284
R2351 VSS.n290 VSS.n155 10.0284
R2352 VSS.n293 VSS.n152 10.0284
R2353 VSS.n294 VSS.n151 10.0284
R2354 VSS.n302 VSS.n148 10.0284
R2355 VSS.n303 VSS.n147 10.0284
R2356 VSS.n307 VSS.n144 10.0284
R2357 VSS.n308 VSS.n143 10.0284
R2358 VSS.n309 VSS.n140 10.0284
R2359 VSS.n310 VSS.n139 10.0284
R2360 VSS.n312 VSS.n135 10.0284
R2361 VSS.n313 VSS.n132 10.0284
R2362 VSS.n314 VSS.n131 10.0284
R2363 VSS.n315 VSS.n128 10.0284
R2364 VSS.t28 VSS.n128 10.0284
R2365 VSS.n317 VSS.n127 10.0284
R2366 VSS.n318 VSS.n124 10.0284
R2367 VSS.n320 VSS.n123 10.0284
R2368 VSS.n322 VSS.n119 10.0284
R2369 VSS.n323 VSS.n116 10.0284
R2370 VSS.n324 VSS.n115 10.0284
R2371 VSS.n325 VSS.n112 10.0284
R2372 VSS.n327 VSS.n111 10.0284
R2373 VSS.n328 VSS.n108 10.0284
R2374 VSS.n332 VSS.n107 10.0284
R2375 VSS.n333 VSS.n104 10.0284
R2376 VSS.n336 VSS.n103 10.0284
R2377 VSS.t30 VSS.n100 10.0284
R2378 VSS.n339 VSS.n99 10.0284
R2379 VSS.n340 VSS.n96 10.0284
R2380 VSS.n344 VSS.n95 10.0284
R2381 VSS.n345 VSS.n92 10.0284
R2382 VSS.n349 VSS.n91 10.0284
R2383 VSS.n350 VSS.n88 10.0284
R2384 VSS.n353 VSS.n87 10.0284
R2385 VSS.n353 VSS.t53 10.0284
R2386 VSS.n354 VSS.n84 10.0284
R2387 VSS.n357 VSS.n83 10.0284
R2388 VSS.n358 VSS.n80 10.0284
R2389 VSS.n363 VSS.n79 10.0284
R2390 VSS.n364 VSS.n76 10.0284
R2391 VSS.n367 VSS.n75 10.0284
R2392 VSS.n2921 VSS.n74 10.0284
R2393 VSS.t34 VSS.n1806 10.0217
R2394 VSS.t185 VSS.t9 9.77726
R2395 VSS.n779 VSS.t14 9.61075
R2396 VSS.n1790 VSS.t187 9.55919
R2397 VSS.t188 VSS.n1790 9.30017
R2398 VSS.n680 VSS.n662 9.28843
R2399 VSS.n682 VSS.n681 9.28843
R2400 VSS.n2116 VSS.n1994 9.28843
R2401 VSS.n2115 VSS.n1993 9.28843
R2402 VSS.n2114 VSS.n1992 9.28843
R2403 VSS.n2113 VSS.n1991 9.28843
R2404 VSS.n2111 VSS.n1989 9.28843
R2405 VSS.n2110 VSS.n1988 9.28843
R2406 VSS.n2109 VSS.n1987 9.28843
R2407 VSS.n2108 VSS.n1986 9.28843
R2408 VSS.n2107 VSS.n1985 9.28843
R2409 VSS.n2106 VSS.n1984 9.28843
R2410 VSS.n2105 VSS.n1983 9.28843
R2411 VSS.n2104 VSS.n1982 9.28843
R2412 VSS.t60 VSS.n1981 9.28843
R2413 VSS.n2103 VSS.n1980 9.28843
R2414 VSS.n2102 VSS.n1979 9.28843
R2415 VSS.n2101 VSS.n1978 9.28843
R2416 VSS.n2100 VSS.n1977 9.28843
R2417 VSS.n2099 VSS.n1976 9.28843
R2418 VSS.n2088 VSS.n1975 9.28843
R2419 VSS.n1908 VSS.n1813 9.19261
R2420 VSS.t64 VSS.n2746 8.59136
R2421 VSS.t116 VSS.n2426 8.51921
R2422 VSS.n2385 VSS.t175 8.50175
R2423 VSS.n1340 VSS.t163 8.50175
R2424 VSS.n2331 VSS.n2087 8.50125
R2425 VSS.n2385 VSS.t176 8.501
R2426 VSS.n2482 VSS.n2428 8.501
R2427 VSS.n1340 VSS.t162 8.501
R2428 VSS.n1917 VSS.n69 8.501
R2429 VSS.n1919 VSS.n69 8.501
R2430 VSS.n1915 VSS.n69 8.501
R2431 VSS.n1924 VSS.n69 8.501
R2432 VSS.n1926 VSS.n69 8.501
R2433 VSS.n1913 VSS.n69 8.501
R2434 VSS.n1931 VSS.n69 8.501
R2435 VSS.n1933 VSS.n69 8.501
R2436 VSS.n1911 VSS.n69 8.501
R2437 VSS.n1938 VSS.n69 8.501
R2438 VSS.n1940 VSS.n69 8.501
R2439 VSS.n1941 VSS.n69 8.501
R2440 VSS.n490 VSS.n489 8.501
R2441 VSS.n2915 VSS.n2914 8.501
R2442 VSS.n931 VSS.n904 8.501
R2443 VSS.n931 VSS.n912 8.501
R2444 VSS.n931 VSS.n914 8.501
R2445 VSS.n931 VSS.n915 8.501
R2446 VSS.n931 VSS.n916 8.501
R2447 VSS.n2919 VSS.n436 8.501
R2448 VSS.n2919 VSS.n437 8.501
R2449 VSS.n2919 VSS.n438 8.501
R2450 VSS.n2919 VSS.n439 8.501
R2451 VSS.n2919 VSS.n440 8.501
R2452 VSS.n2919 VSS.n441 8.501
R2453 VSS.n2919 VSS.n442 8.501
R2454 VSS.n2919 VSS.n443 8.501
R2455 VSS.n2919 VSS.n444 8.501
R2456 VSS.n2919 VSS.n445 8.501
R2457 VSS.n2919 VSS.n446 8.501
R2458 VSS.n2919 VSS.n447 8.501
R2459 VSS.n2920 VSS.n434 8.501
R2460 VSS.n2920 VSS.n433 8.501
R2461 VSS.n2920 VSS.n432 8.501
R2462 VSS.n2920 VSS.n431 8.501
R2463 VSS.n2920 VSS.n430 8.501
R2464 VSS.n2920 VSS.n429 8.501
R2465 VSS.n2920 VSS.n428 8.501
R2466 VSS.n2920 VSS.n427 8.501
R2467 VSS.n2920 VSS.n426 8.501
R2468 VSS.n2920 VSS.n425 8.501
R2469 VSS.n2920 VSS.n424 8.501
R2470 VSS.n2920 VSS.n423 8.501
R2471 VSS.n2920 VSS.n422 8.501
R2472 VSS.n2920 VSS.n421 8.501
R2473 VSS.n2920 VSS.n420 8.501
R2474 VSS.n2920 VSS.n419 8.501
R2475 VSS.n2920 VSS.n418 8.501
R2476 VSS.n2920 VSS.n417 8.501
R2477 VSS.n2920 VSS.n416 8.501
R2478 VSS.n2920 VSS.n415 8.501
R2479 VSS.n2920 VSS.n414 8.501
R2480 VSS.n2920 VSS.n413 8.501
R2481 VSS.n2920 VSS.n412 8.501
R2482 VSS.n2920 VSS.n411 8.501
R2483 VSS.n2920 VSS.n410 8.501
R2484 VSS.n2920 VSS.n409 8.501
R2485 VSS.n2920 VSS.n395 8.501
R2486 VSS.n2920 VSS.n394 8.501
R2487 VSS.n2920 VSS.n393 8.501
R2488 VSS.n2920 VSS.n392 8.501
R2489 VSS.n2920 VSS.n391 8.501
R2490 VSS.n2920 VSS.n390 8.501
R2491 VSS.n2920 VSS.n389 8.501
R2492 VSS.n2920 VSS.n388 8.501
R2493 VSS.n2920 VSS.n387 8.501
R2494 VSS.n2920 VSS.n386 8.501
R2495 VSS.n2920 VSS.n385 8.501
R2496 VSS.n236 VSS.n71 8.501
R2497 VSS.n249 VSS.n71 8.501
R2498 VSS.n247 VSS.n71 8.501
R2499 VSS.n245 VSS.n71 8.501
R2500 VSS.n243 VSS.n71 8.501
R2501 VSS.n241 VSS.n71 8.501
R2502 VSS.n239 VSS.n71 8.501
R2503 VSS.n237 VSS.n71 8.501
R2504 VSS.n2921 VSS.n384 8.501
R2505 VSS.n2921 VSS.n375 8.501
R2506 VSS.n2921 VSS.n374 8.501
R2507 VSS.n2921 VSS.n373 8.501
R2508 VSS.n2921 VSS.n372 8.501
R2509 VSS.n2921 VSS.n371 8.501
R2510 VSS.n2921 VSS.n370 8.501
R2511 VSS.n2921 VSS.n369 8.501
R2512 VSS.n2744 VSS.n2522 8.501
R2513 VSS.n2744 VSS.n2523 8.501
R2514 VSS.n2744 VSS.n2524 8.501
R2515 VSS.n2744 VSS.n2525 8.501
R2516 VSS.n2744 VSS.n2526 8.501
R2517 VSS.n2744 VSS.n2527 8.501
R2518 VSS.n2744 VSS.n2528 8.501
R2519 VSS.n2744 VSS.n2529 8.501
R2520 VSS.n2744 VSS.n2530 8.501
R2521 VSS.n2744 VSS.n2531 8.501
R2522 VSS.n2744 VSS.n2532 8.501
R2523 VSS.n2744 VSS.n2533 8.501
R2524 VSS.n2744 VSS.n2534 8.501
R2525 VSS.n2744 VSS.n2535 8.501
R2526 VSS.n2744 VSS.n2536 8.501
R2527 VSS.n2744 VSS.n2537 8.501
R2528 VSS.n2744 VSS.n2538 8.501
R2529 VSS.n2744 VSS.n2539 8.501
R2530 VSS.n2744 VSS.n2540 8.501
R2531 VSS.n2744 VSS.n2541 8.501
R2532 VSS.n2744 VSS.n2542 8.501
R2533 VSS.n2744 VSS.n2543 8.501
R2534 VSS.n2744 VSS.n2544 8.501
R2535 VSS.n2744 VSS.n2545 8.501
R2536 VSS.n2744 VSS.n2546 8.501
R2537 VSS.n2744 VSS.n2547 8.501
R2538 VSS.n2744 VSS.n2548 8.501
R2539 VSS.n2744 VSS.n2549 8.501
R2540 VSS.n2744 VSS.n2550 8.501
R2541 VSS.n2744 VSS.n2551 8.501
R2542 VSS.n2744 VSS.n2743 8.501
R2543 VSS.n2751 VSS.n2443 8.501
R2544 VSS.n2751 VSS.n2444 8.501
R2545 VSS.n2751 VSS.n2445 8.501
R2546 VSS.n2751 VSS.n2446 8.501
R2547 VSS.n2751 VSS.n2447 8.501
R2548 VSS.n2751 VSS.n2448 8.501
R2549 VSS.n2751 VSS.n2449 8.501
R2550 VSS.n2751 VSS.n2450 8.501
R2551 VSS.n2751 VSS.n2451 8.501
R2552 VSS.n2751 VSS.n2452 8.501
R2553 VSS.n2751 VSS.n2453 8.501
R2554 VSS.n2751 VSS.n2454 8.501
R2555 VSS.n2751 VSS.n2455 8.501
R2556 VSS.n2751 VSS.n2456 8.501
R2557 VSS.n2751 VSS.n2457 8.501
R2558 VSS.n2751 VSS.n2458 8.501
R2559 VSS.n2751 VSS.n2423 8.501
R2560 VSS.n2751 VSS.n2424 8.501
R2561 VSS.n2751 VSS.n2439 8.501
R2562 VSS.n2752 VSS.n2751 8.501
R2563 VSS.n2751 VSS.n2459 8.501
R2564 VSS.n2751 VSS.n2463 8.501
R2565 VSS.n2751 VSS.n2467 8.501
R2566 VSS.n2751 VSS.n2468 8.501
R2567 VSS.n2751 VSS.n2469 8.501
R2568 VSS.n2751 VSS.n2470 8.501
R2569 VSS.n2751 VSS.n2471 8.501
R2570 VSS.n2751 VSS.n2472 8.501
R2571 VSS.n2751 VSS.n2473 8.501
R2572 VSS.n2751 VSS.n2519 8.501
R2573 VSS.n1117 VSS.n1024 8.501
R2574 VSS.n1117 VSS.n1025 8.501
R2575 VSS.n1117 VSS.n1026 8.501
R2576 VSS.n1117 VSS.n1027 8.501
R2577 VSS.n1117 VSS.n1028 8.501
R2578 VSS.n1117 VSS.n1029 8.501
R2579 VSS.n1117 VSS.n1030 8.501
R2580 VSS.n1117 VSS.n1031 8.501
R2581 VSS.n1117 VSS.n1032 8.501
R2582 VSS.n1117 VSS.n1033 8.501
R2583 VSS.n1117 VSS.n1034 8.501
R2584 VSS.n1117 VSS.n1035 8.501
R2585 VSS.n1117 VSS.n1036 8.501
R2586 VSS.n1117 VSS.n1037 8.501
R2587 VSS.n1117 VSS.n1038 8.501
R2588 VSS.n1117 VSS.n1039 8.501
R2589 VSS.n1117 VSS.n1040 8.501
R2590 VSS.n1117 VSS.n1041 8.501
R2591 VSS.n1117 VSS.n1042 8.501
R2592 VSS.n1117 VSS.n1043 8.501
R2593 VSS.n1117 VSS.n1044 8.501
R2594 VSS.n1117 VSS.n1045 8.501
R2595 VSS.n1117 VSS.n1046 8.501
R2596 VSS.n1117 VSS.n1047 8.501
R2597 VSS.n1117 VSS.n1048 8.501
R2598 VSS.n1117 VSS.n1049 8.501
R2599 VSS.n1117 VSS.n1050 8.501
R2600 VSS.n1117 VSS.n1051 8.501
R2601 VSS.n1117 VSS.n1052 8.501
R2602 VSS.n1011 VSS.n1010 8.501
R2603 VSS.n1132 VSS.n645 8.501
R2604 VSS.n1134 VSS.n645 8.501
R2605 VSS.n1152 VSS.n645 8.501
R2606 VSS.n1149 VSS.n645 8.501
R2607 VSS.n1142 VSS.n645 8.501
R2608 VSS.n2881 VSS.n616 8.501
R2609 VSS.n2881 VSS.n617 8.501
R2610 VSS.n2881 VSS.n618 8.501
R2611 VSS.n2881 VSS.n619 8.501
R2612 VSS.n2881 VSS.n620 8.501
R2613 VSS.n2881 VSS.n621 8.501
R2614 VSS.n2881 VSS.n622 8.501
R2615 VSS.n2881 VSS.n623 8.501
R2616 VSS.n2881 VSS.n624 8.501
R2617 VSS.n2881 VSS.n625 8.501
R2618 VSS.n2881 VSS.n626 8.501
R2619 VSS.n2881 VSS.n627 8.501
R2620 VSS.n2881 VSS.n628 8.501
R2621 VSS.n2881 VSS.n629 8.501
R2622 VSS.n2881 VSS.n606 8.501
R2623 VSS.n2881 VSS.n607 8.501
R2624 VSS.n2882 VSS.n2881 8.501
R2625 VSS.n2881 VSS.n630 8.501
R2626 VSS.n2881 VSS.n631 8.501
R2627 VSS.n2881 VSS.n632 8.501
R2628 VSS.n2881 VSS.n633 8.501
R2629 VSS.n2881 VSS.n634 8.501
R2630 VSS.n2881 VSS.n635 8.501
R2631 VSS.n2881 VSS.n636 8.501
R2632 VSS.n2881 VSS.n637 8.501
R2633 VSS.n2881 VSS.n638 8.501
R2634 VSS.n2881 VSS.n639 8.501
R2635 VSS.n2881 VSS.n640 8.501
R2636 VSS.n2881 VSS.n641 8.501
R2637 VSS.n2881 VSS.n642 8.501
R2638 VSS.n2881 VSS.n643 8.501
R2639 VSS.n2881 VSS.n644 8.501
R2640 VSS.n1607 VSS.n938 8.501
R2641 VSS.n1607 VSS.n940 8.501
R2642 VSS.n1607 VSS.n942 8.501
R2643 VSS.n1607 VSS.n944 8.501
R2644 VSS.n1607 VSS.n946 8.501
R2645 VSS.n1607 VSS.n948 8.501
R2646 VSS.n1607 VSS.n950 8.501
R2647 VSS.n1607 VSS.n952 8.501
R2648 VSS.n1607 VSS.n954 8.501
R2649 VSS.n1607 VSS.n956 8.501
R2650 VSS.n1607 VSS.n958 8.501
R2651 VSS.n1607 VSS.n960 8.501
R2652 VSS.n1607 VSS.n962 8.501
R2653 VSS.n1607 VSS.n964 8.501
R2654 VSS.n1608 VSS.n1607 8.501
R2655 VSS.n1607 VSS.n611 8.501
R2656 VSS.n1607 VSS.n612 8.501
R2657 VSS.n1607 VSS.n966 8.501
R2658 VSS.n1607 VSS.n967 8.501
R2659 VSS.n1607 VSS.n968 8.501
R2660 VSS.n1607 VSS.n969 8.501
R2661 VSS.n1607 VSS.n970 8.501
R2662 VSS.n1607 VSS.n971 8.501
R2663 VSS.n1607 VSS.n972 8.501
R2664 VSS.n1607 VSS.n973 8.501
R2665 VSS.n1607 VSS.n974 8.501
R2666 VSS.n1607 VSS.n975 8.501
R2667 VSS.n1607 VSS.n976 8.501
R2668 VSS.n1607 VSS.n977 8.501
R2669 VSS.n1607 VSS.n978 8.501
R2670 VSS.n1607 VSS.n979 8.501
R2671 VSS.n1607 VSS.n980 8.501
R2672 VSS.n1607 VSS.n981 8.501
R2673 VSS.n1607 VSS.n982 8.501
R2674 VSS.n1607 VSS.n983 8.501
R2675 VSS.n1607 VSS.n984 8.501
R2676 VSS.n1607 VSS.n985 8.501
R2677 VSS.n1607 VSS.n986 8.501
R2678 VSS.n1607 VSS.n987 8.501
R2679 VSS.n1607 VSS.n988 8.501
R2680 VSS.n1907 VSS.n1832 8.501
R2681 VSS.n1907 VSS.n1831 8.501
R2682 VSS.n1907 VSS.n1830 8.501
R2683 VSS.n1907 VSS.n1829 8.501
R2684 VSS.n1907 VSS.n1828 8.501
R2685 VSS.n1907 VSS.n1827 8.501
R2686 VSS.n1907 VSS.n1826 8.501
R2687 VSS.n1907 VSS.n1825 8.501
R2688 VSS.n1907 VSS.n1824 8.501
R2689 VSS.n1907 VSS.n1823 8.501
R2690 VSS.n1907 VSS.n1822 8.501
R2691 VSS.n1907 VSS.n1821 8.501
R2692 VSS.n1907 VSS.n1820 8.501
R2693 VSS.n1907 VSS.n1819 8.501
R2694 VSS.n1907 VSS.n1818 8.501
R2695 VSS.n1907 VSS.n1817 8.501
R2696 VSS.n1907 VSS.n1816 8.501
R2697 VSS.n1907 VSS.n1815 8.501
R2698 VSS.n1907 VSS.n1814 8.501
R2699 VSS.n1904 VSS.n1903 8.501
R2700 VSS.n2874 VSS.n1689 8.501
R2701 VSS.n2874 VSS.n1688 8.501
R2702 VSS.n2874 VSS.n1687 8.501
R2703 VSS.n2874 VSS.n1686 8.501
R2704 VSS.n2874 VSS.n1685 8.501
R2705 VSS.n2874 VSS.n1684 8.501
R2706 VSS.n2874 VSS.n1683 8.501
R2707 VSS.n2874 VSS.n1682 8.501
R2708 VSS.n2874 VSS.n1681 8.501
R2709 VSS.n2874 VSS.n1680 8.501
R2710 VSS.n2874 VSS.n1679 8.501
R2711 VSS.n2878 VSS.n721 8.501
R2712 VSS.n2878 VSS.n720 8.501
R2713 VSS.n2878 VSS.n719 8.501
R2714 VSS.n2878 VSS.n718 8.501
R2715 VSS.n2878 VSS.n717 8.501
R2716 VSS.n2878 VSS.n716 8.501
R2717 VSS.n2878 VSS.n715 8.501
R2718 VSS.n2878 VSS.n714 8.501
R2719 VSS.n2878 VSS.n713 8.501
R2720 VSS.n2878 VSS.n712 8.501
R2721 VSS.n2878 VSS.n711 8.501
R2722 VSS.n2878 VSS.n710 8.501
R2723 VSS.n2878 VSS.n709 8.501
R2724 VSS.n2878 VSS.n708 8.501
R2725 VSS.n2878 VSS.n707 8.501
R2726 VSS.n2931 VSS.n66 8.501
R2727 VSS.n2931 VSS.n65 8.501
R2728 VSS.n2931 VSS.n64 8.501
R2729 VSS.n2931 VSS.n63 8.501
R2730 VSS.n2931 VSS.n62 8.501
R2731 VSS.n2931 VSS.n61 8.501
R2732 VSS.n2931 VSS.n60 8.501
R2733 VSS.n2931 VSS.n59 8.501
R2734 VSS.n2931 VSS.n58 8.501
R2735 VSS.n2931 VSS.n57 8.501
R2736 VSS.n2931 VSS.n56 8.501
R2737 VSS.n2931 VSS.n55 8.501
R2738 VSS.n2931 VSS.n54 8.501
R2739 VSS.n2931 VSS.n53 8.501
R2740 VSS.n2931 VSS.n52 8.501
R2741 VSS.n2931 VSS.n51 8.501
R2742 VSS.n2931 VSS.n50 8.501
R2743 VSS.n2931 VSS.n49 8.501
R2744 VSS.n2931 VSS.n48 8.501
R2745 VSS.n2931 VSS.n47 8.501
R2746 VSS.n2931 VSS.n46 8.501
R2747 VSS.n2931 VSS.n45 8.501
R2748 VSS.n2931 VSS.n44 8.501
R2749 VSS.n2931 VSS.n43 8.501
R2750 VSS.n2931 VSS.n42 8.501
R2751 VSS.n2931 VSS.n41 8.501
R2752 VSS.n2931 VSS.n34 8.501
R2753 VSS.n2932 VSS.n2931 8.501
R2754 VSS.n2931 VSS.n40 8.501
R2755 VSS.n2931 VSS.n39 8.501
R2756 VSS.n2931 VSS.n38 8.501
R2757 VSS.n2486 VSS.t116 8.5005
R2758 VSS.n2477 VSS.t116 8.5005
R2759 VSS.n2490 VSS.t116 8.5005
R2760 VSS.n2476 VSS.t116 8.5005
R2761 VSS.n2494 VSS.t116 8.5005
R2762 VSS.n2475 VSS.t116 8.5005
R2763 VSS.n2498 VSS.t116 8.5005
R2764 VSS.n2474 VSS.t116 8.5005
R2765 VSS.n2502 VSS.t116 8.5005
R2766 VSS.n2516 VSS.t116 8.5005
R2767 VSS.n2514 VSS.t116 8.5005
R2768 VSS.n2512 VSS.t116 8.5005
R2769 VSS.n2510 VSS.t116 8.5005
R2770 VSS.t33 VSS.n214 8.5005
R2771 VSS.t33 VSS.n213 8.5005
R2772 VSS.t33 VSS.n215 8.5005
R2773 VSS.t33 VSS.n212 8.5005
R2774 VSS.t33 VSS.n219 8.5005
R2775 VSS.t33 VSS.n211 8.5005
R2776 VSS.t31 VSS.n1460 8.5005
R2777 VSS.t31 VSS.n1408 8.5005
R2778 VSS.t31 VSS.n1409 8.5005
R2779 VSS.t31 VSS.n1413 8.5005
R2780 VSS.t31 VSS.n1414 8.5005
R2781 VSS.t31 VSS.n1418 8.5005
R2782 VSS.t31 VSS.n1419 8.5005
R2783 VSS.t31 VSS.n1423 8.5005
R2784 VSS.t31 VSS.n1424 8.5005
R2785 VSS.t31 VSS.n1428 8.5005
R2786 VSS.t31 VSS.n1429 8.5005
R2787 VSS.t31 VSS.n1430 8.5005
R2788 VSS.t31 VSS.n1434 8.5005
R2789 VSS.t31 VSS.n1435 8.5005
R2790 VSS.t31 VSS.n1439 8.5005
R2791 VSS.t31 VSS.n1440 8.5005
R2792 VSS.t31 VSS.n1444 8.5005
R2793 VSS.t31 VSS.n1445 8.5005
R2794 VSS.t31 VSS.n1449 8.5005
R2795 VSS.t31 VSS.n1450 8.5005
R2796 VSS.t31 VSS.n1457 8.5005
R2797 VSS.n1461 VSS.t31 8.5005
R2798 VSS.n1571 VSS.t44 8.5005
R2799 VSS.t44 VSS.n1286 8.5005
R2800 VSS.n1585 VSS.n1584 8.5005
R2801 VSS.n1585 VSS.n1583 8.5005
R2802 VSS.n1585 VSS.n1582 8.5005
R2803 VSS.n1585 VSS.n1581 8.5005
R2804 VSS.n1585 VSS.n1580 8.5005
R2805 VSS.n1585 VSS.n1579 8.5005
R2806 VSS.n1585 VSS.n1578 8.5005
R2807 VSS.n1585 VSS.n1577 8.5005
R2808 VSS.n1585 VSS.n1576 8.5005
R2809 VSS.n1585 VSS.n1575 8.5005
R2810 VSS.n1585 VSS.n1574 8.5005
R2811 VSS.n408 VSS.n407 8.5005
R2812 VSS.n407 VSS.n406 8.5005
R2813 VSS.n407 VSS.n405 8.5005
R2814 VSS.n407 VSS.n404 8.5005
R2815 VSS.n407 VSS.n403 8.5005
R2816 VSS.n407 VSS.n402 8.5005
R2817 VSS.n407 VSS.n401 8.5005
R2818 VSS.n407 VSS.n400 8.5005
R2819 VSS.n407 VSS.n399 8.5005
R2820 VSS.n407 VSS.n398 8.5005
R2821 VSS.n407 VSS.n397 8.5005
R2822 VSS.n407 VSS.n396 8.5005
R2823 VSS.n252 VSS.n251 8.5005
R2824 VSS.n251 VSS.n250 8.5005
R2825 VSS.n251 VSS.n248 8.5005
R2826 VSS.n251 VSS.n246 8.5005
R2827 VSS.n251 VSS.n244 8.5005
R2828 VSS.n251 VSS.n242 8.5005
R2829 VSS.n251 VSS.n240 8.5005
R2830 VSS.n251 VSS.n238 8.5005
R2831 VSS.n383 VSS.n382 8.5005
R2832 VSS.n382 VSS.n376 8.5005
R2833 VSS.n382 VSS.n377 8.5005
R2834 VSS.n382 VSS.n378 8.5005
R2835 VSS.n382 VSS.n379 8.5005
R2836 VSS.n382 VSS.n380 8.5005
R2837 VSS.n382 VSS.n381 8.5005
R2838 VSS.n382 VSS.n368 8.5005
R2839 VSS.n1235 VSS.n1006 8.5005
R2840 VSS.n1235 VSS.n1005 8.5005
R2841 VSS.n1235 VSS.n1004 8.5005
R2842 VSS.n1235 VSS.n1003 8.5005
R2843 VSS.n1235 VSS.n1002 8.5005
R2844 VSS.n1235 VSS.n1001 8.5005
R2845 VSS.n1235 VSS.n1000 8.5005
R2846 VSS.n1240 VSS.n997 8.5005
R2847 VSS.n1240 VSS.n996 8.5005
R2848 VSS.n1240 VSS.n995 8.5005
R2849 VSS.n1240 VSS.n994 8.5005
R2850 VSS.n1240 VSS.n993 8.5005
R2851 VSS.n1240 VSS.n992 8.5005
R2852 VSS.n1240 VSS.n991 8.5005
R2853 VSS.n2332 VSS.n2331 8.5005
R2854 VSS.n2331 VSS.n2261 8.5005
R2855 VSS.n2331 VSS.n2260 8.5005
R2856 VSS.n2331 VSS.n2259 8.5005
R2857 VSS.n2331 VSS.n2258 8.5005
R2858 VSS.n2331 VSS.n2257 8.5005
R2859 VSS.n2331 VSS.n2256 8.5005
R2860 VSS.n2331 VSS.n2255 8.5005
R2861 VSS.n2331 VSS.n2254 8.5005
R2862 VSS.n2331 VSS.n2253 8.5005
R2863 VSS.n2331 VSS.n2252 8.5005
R2864 VSS.n2331 VSS.n2251 8.5005
R2865 VSS.n2331 VSS.n2250 8.5005
R2866 VSS.n2331 VSS.n2249 8.5005
R2867 VSS.n2331 VSS.n2248 8.5005
R2868 VSS.n2331 VSS.n2247 8.5005
R2869 VSS.n2331 VSS.n2246 8.5005
R2870 VSS.n2331 VSS.n2182 8.5005
R2871 VSS.n2331 VSS.n2181 8.5005
R2872 VSS.n2331 VSS.n2116 8.5005
R2873 VSS.n2331 VSS.n2115 8.5005
R2874 VSS.n2331 VSS.n2114 8.5005
R2875 VSS.n2331 VSS.n2113 8.5005
R2876 VSS.n2331 VSS.n2112 8.5005
R2877 VSS.n2331 VSS.n2111 8.5005
R2878 VSS.n2331 VSS.n2110 8.5005
R2879 VSS.n2331 VSS.n2109 8.5005
R2880 VSS.n2331 VSS.n2108 8.5005
R2881 VSS.n2331 VSS.n2107 8.5005
R2882 VSS.n2331 VSS.n2106 8.5005
R2883 VSS.n2331 VSS.n2105 8.5005
R2884 VSS.n2331 VSS.n2104 8.5005
R2885 VSS.n2331 VSS.t60 8.5005
R2886 VSS.n2331 VSS.n2103 8.5005
R2887 VSS.n2331 VSS.n2102 8.5005
R2888 VSS.n2331 VSS.n2101 8.5005
R2889 VSS.n2331 VSS.n2100 8.5005
R2890 VSS.n2331 VSS.n2099 8.5005
R2891 VSS.n2872 VSS.n2008 8.5005
R2892 VSS.n2872 VSS.n2007 8.5005
R2893 VSS.n2872 VSS.n2006 8.5005
R2894 VSS.n2872 VSS.n2005 8.5005
R2895 VSS.n2872 VSS.n2004 8.5005
R2896 VSS.n2872 VSS.n2003 8.5005
R2897 VSS.n2872 VSS.n2002 8.5005
R2898 VSS.n2872 VSS.n2001 8.5005
R2899 VSS.n2872 VSS.n2000 8.5005
R2900 VSS.n2872 VSS.n1999 8.5005
R2901 VSS.n2872 VSS.n1998 8.5005
R2902 VSS.n2872 VSS.n1997 8.5005
R2903 VSS.n2872 VSS.n1995 8.5005
R2904 VSS.n2872 VSS.n1994 8.5005
R2905 VSS.n2872 VSS.n1993 8.5005
R2906 VSS.n2872 VSS.n1992 8.5005
R2907 VSS.n2872 VSS.n1991 8.5005
R2908 VSS.n2872 VSS.n1990 8.5005
R2909 VSS.n2872 VSS.n1989 8.5005
R2910 VSS.n2872 VSS.n1988 8.5005
R2911 VSS.n2872 VSS.n1987 8.5005
R2912 VSS.n2872 VSS.n1986 8.5005
R2913 VSS.n2872 VSS.n1985 8.5005
R2914 VSS.n2872 VSS.n1984 8.5005
R2915 VSS.n2872 VSS.n1983 8.5005
R2916 VSS.n2872 VSS.n1982 8.5005
R2917 VSS.n2880 VSS.n647 8.5005
R2918 VSS.n673 VSS.n647 8.5005
R2919 VSS.n668 VSS.n647 8.5005
R2920 VSS.n674 VSS.n647 8.5005
R2921 VSS.n667 VSS.n647 8.5005
R2922 VSS.n675 VSS.n647 8.5005
R2923 VSS.n666 VSS.n647 8.5005
R2924 VSS.n676 VSS.n647 8.5005
R2925 VSS.n665 VSS.n647 8.5005
R2926 VSS.n677 VSS.n647 8.5005
R2927 VSS.n664 VSS.n647 8.5005
R2928 VSS.n678 VSS.n647 8.5005
R2929 VSS.n663 VSS.n647 8.5005
R2930 VSS.n679 VSS.n647 8.5005
R2931 VSS.n662 VSS.n647 8.5005
R2932 VSS.n682 VSS.n647 8.5005
R2933 VSS.n661 VSS.n647 8.5005
R2934 VSS.n684 VSS.n647 8.5005
R2935 VSS.n660 VSS.n647 8.5005
R2936 VSS.n686 VSS.n647 8.5005
R2937 VSS.n659 VSS.n647 8.5005
R2938 VSS.n689 VSS.n647 8.5005
R2939 VSS.n658 VSS.n647 8.5005
R2940 VSS.n691 VSS.n647 8.5005
R2941 VSS.n657 VSS.n647 8.5005
R2942 VSS.n695 VSS.n647 8.5005
R2943 VSS.n656 VSS.n647 8.5005
R2944 VSS.n697 VSS.n647 8.5005
R2945 VSS.n655 VSS.n647 8.5005
R2946 VSS.n700 VSS.n647 8.5005
R2947 VSS.n654 VSS.n647 8.5005
R2948 VSS.n702 VSS.n647 8.5005
R2949 VSS.n653 VSS.n647 8.5005
R2950 VSS.n705 VSS.n647 8.5005
R2951 VSS.n652 VSS.n647 8.5005
R2952 VSS.n2879 VSS.n670 8.5005
R2953 VSS.n2879 VSS.n615 8.5005
R2954 VSS.n2880 VSS.n2879 8.5005
R2955 VSS.n2879 VSS.n673 8.5005
R2956 VSS.n2879 VSS.n668 8.5005
R2957 VSS.n2879 VSS.n674 8.5005
R2958 VSS.n2879 VSS.n667 8.5005
R2959 VSS.n2879 VSS.n675 8.5005
R2960 VSS.n2879 VSS.n666 8.5005
R2961 VSS.n2879 VSS.n676 8.5005
R2962 VSS.n2879 VSS.n665 8.5005
R2963 VSS.n2879 VSS.n677 8.5005
R2964 VSS.n2879 VSS.n664 8.5005
R2965 VSS.n2879 VSS.n678 8.5005
R2966 VSS.n2879 VSS.n663 8.5005
R2967 VSS.n2879 VSS.n679 8.5005
R2968 VSS.n2879 VSS.n662 8.5005
R2969 VSS.n2879 VSS.n682 8.5005
R2970 VSS.n2879 VSS.n661 8.5005
R2971 VSS.n2879 VSS.n684 8.5005
R2972 VSS.n2879 VSS.n660 8.5005
R2973 VSS.n2879 VSS.n686 8.5005
R2974 VSS.n2879 VSS.n659 8.5005
R2975 VSS.n2879 VSS.n689 8.5005
R2976 VSS.n2879 VSS.n658 8.5005
R2977 VSS.n2879 VSS.n691 8.5005
R2978 VSS.n2879 VSS.n657 8.5005
R2979 VSS.n2879 VSS.n695 8.5005
R2980 VSS.n2879 VSS.n656 8.5005
R2981 VSS.n2879 VSS.n697 8.5005
R2982 VSS.n2879 VSS.n655 8.5005
R2983 VSS.n2879 VSS.n700 8.5005
R2984 VSS.n2879 VSS.n654 8.5005
R2985 VSS.n2879 VSS.n702 8.5005
R2986 VSS.n2879 VSS.n653 8.5005
R2987 VSS.n2879 VSS.n705 8.5005
R2988 VSS.n2879 VSS.n652 8.5005
R2989 VSS.n2872 VSS.n1981 8.5005
R2990 VSS.n2872 VSS.n1980 8.5005
R2991 VSS.n2872 VSS.n1979 8.5005
R2992 VSS.n2872 VSS.n1978 8.5005
R2993 VSS.n2872 VSS.n1977 8.5005
R2994 VSS.n2872 VSS.n1976 8.5005
R2995 VSS.n2872 VSS.n1975 8.5005
R2996 VSS.n2872 VSS.n2013 8.5005
R2997 VSS.n2872 VSS.n2012 8.5005
R2998 VSS.n2872 VSS.n2011 8.5005
R2999 VSS.n2872 VSS.t112 8.5005
R3000 VSS.n2872 VSS.n2085 8.5005
R3001 VSS.n2872 VSS.n2086 8.5005
R3002 VSS.n2872 VSS.n2333 8.5005
R3003 VSS.n1565 VSS.n70 8.49985
R3004 VSS.n2923 VSS.n362 8.49959
R3005 VSS.n2923 VSS.n356 8.49959
R3006 VSS.n2923 VSS.n348 8.49959
R3007 VSS.n2923 VSS.n338 8.49959
R3008 VSS.n2923 VSS.n331 8.49959
R3009 VSS.n2923 VSS.n289 8.49959
R3010 VSS.n2923 VSS.n279 8.49959
R3011 VSS.n2923 VSS.n255 8.49959
R3012 VSS.n365 VSS.n234 8.49959
R3013 VSS.n254 VSS.n234 8.49959
R3014 VSS.n1224 VSS.n499 8.49931
R3015 VSS.n1229 VSS.n499 8.49931
R3016 VSS.n907 VSS.n903 8.49921
R3017 VSS.n913 VSS.n496 8.49921
R3018 VSS.n919 VSS.n918 8.49921
R3019 VSS.n929 VSS.n928 8.49921
R3020 VSS.n1145 VSS.n1144 8.49901
R3021 VSS.n1130 VSS.n1129 8.49898
R3022 VSS.n1165 VSS.n1129 8.49898
R3023 VSS.n2872 VSS.n1693 8.49839
R3024 VSS.n2872 VSS.n1751 8.49839
R3025 VSS.n2872 VSS.n1752 8.49839
R3026 VSS.n2872 VSS.n2078 8.49839
R3027 VSS.n2872 VSS.n2072 8.49839
R3028 VSS.n2870 VSS.n2334 8.49839
R3029 VSS.t157 VSS.n1407 8.49791
R3030 VSS.n2926 VSS.n206 8.49791
R3031 VSS.n2926 VSS.n188 8.49791
R3032 VSS.n2926 VSS.n187 8.49791
R3033 VSS.n1462 VSS.n1406 8.49791
R3034 VSS.n1459 VSS.n1458 8.49791
R3035 VSS.n1456 VSS.n1455 8.49791
R3036 VSS.t157 VSS.n1451 8.49786
R3037 VSS.t148 VSS.n2263 8.49751
R3038 VSS.t148 VSS.n2265 8.49751
R3039 VSS.t148 VSS.n2267 8.49751
R3040 VSS.t148 VSS.n2269 8.49751
R3041 VSS.t148 VSS.n2273 8.49751
R3042 VSS.t148 VSS.n2277 8.49751
R3043 VSS.t148 VSS.n2279 8.49751
R3044 VSS.t148 VSS.n2281 8.49751
R3045 VSS.t148 VSS.n2283 8.49751
R3046 VSS.t148 VSS.n2287 8.49751
R3047 VSS.t113 VSS.n2302 8.49751
R3048 VSS.t113 VSS.n2313 8.49751
R3049 VSS.t113 VSS.n2312 8.49751
R3050 VSS.t113 VSS.n2311 8.49751
R3051 VSS.t113 VSS.n2310 8.49751
R3052 VSS.t113 VSS.n2308 8.49751
R3053 VSS.t113 VSS.n2306 8.49751
R3054 VSS.t113 VSS.n2305 8.49751
R3055 VSS.t113 VSS.n2304 8.49751
R3056 VSS.t113 VSS.n2303 8.49751
R3057 VSS.t114 VSS.n2317 8.49751
R3058 VSS.t114 VSS.n2301 8.49751
R3059 VSS.t114 VSS.n2300 8.49751
R3060 VSS.t114 VSS.n2298 8.49751
R3061 VSS.t114 VSS.n2296 8.49751
R3062 VSS.t114 VSS.n2295 8.49751
R3063 VSS.t114 VSS.n2294 8.49751
R3064 VSS.t114 VSS.n2293 8.49751
R3065 VSS.t114 VSS.n2291 8.49751
R3066 VSS.t114 VSS.n2289 8.49751
R3067 VSS.n2320 VSS.t149 8.49751
R3068 VSS.n2286 VSS.t149 8.49751
R3069 VSS.n2284 VSS.t149 8.49751
R3070 VSS.n2280 VSS.t149 8.49751
R3071 VSS.n2276 VSS.t149 8.49751
R3072 VSS.n2274 VSS.t149 8.49751
R3073 VSS.n2272 VSS.t149 8.49751
R3074 VSS.n2270 VSS.t149 8.49751
R3075 VSS.n2266 VSS.t149 8.49751
R3076 VSS.n2262 VSS.t149 8.49751
R3077 VSS.t142 VSS.n2157 8.49751
R3078 VSS.t142 VSS.n2168 8.49751
R3079 VSS.t142 VSS.n2167 8.49751
R3080 VSS.t142 VSS.n2166 8.49751
R3081 VSS.t142 VSS.n2165 8.49751
R3082 VSS.t142 VSS.n2163 8.49751
R3083 VSS.t142 VSS.n2161 8.49751
R3084 VSS.t142 VSS.n2160 8.49751
R3085 VSS.t142 VSS.n2159 8.49751
R3086 VSS.t142 VSS.n2158 8.49751
R3087 VSS.t61 VSS.n2142 8.49751
R3088 VSS.t61 VSS.n2138 8.49751
R3089 VSS.t61 VSS.n2136 8.49751
R3090 VSS.t61 VSS.n2134 8.49751
R3091 VSS.t61 VSS.n2132 8.49751
R3092 VSS.t61 VSS.n2128 8.49751
R3093 VSS.t61 VSS.n2124 8.49751
R3094 VSS.t61 VSS.n2122 8.49751
R3095 VSS.t61 VSS.n2120 8.49751
R3096 VSS.t61 VSS.n2118 8.49751
R3097 VSS.t143 VSS.n2172 8.49751
R3098 VSS.t143 VSS.n2156 8.49751
R3099 VSS.t143 VSS.n2155 8.49751
R3100 VSS.t143 VSS.n2153 8.49751
R3101 VSS.t143 VSS.n2151 8.49751
R3102 VSS.t143 VSS.n2150 8.49751
R3103 VSS.t143 VSS.n2149 8.49751
R3104 VSS.t143 VSS.n2148 8.49751
R3105 VSS.t143 VSS.n2146 8.49751
R3106 VSS.t143 VSS.n2144 8.49751
R3107 VSS.n2175 VSS.t62 8.49751
R3108 VSS.n2141 VSS.t62 8.49751
R3109 VSS.n2139 VSS.t62 8.49751
R3110 VSS.n2135 VSS.t62 8.49751
R3111 VSS.n2131 VSS.t62 8.49751
R3112 VSS.n2129 VSS.t62 8.49751
R3113 VSS.n2127 VSS.t62 8.49751
R3114 VSS.n2125 VSS.t62 8.49751
R3115 VSS.n2121 VSS.t62 8.49751
R3116 VSS.n2117 VSS.t62 8.49751
R3117 VSS.n2438 VSS.n2427 8.49751
R3118 VSS.n2518 VSS.n2517 8.49751
R3119 VSS.t148 VSS.n2271 8.49746
R3120 VSS.t148 VSS.n2275 8.49746
R3121 VSS.t148 VSS.n2285 8.49746
R3122 VSS.t113 VSS.n2314 8.49746
R3123 VSS.t113 VSS.n2309 8.49746
R3124 VSS.t113 VSS.n2307 8.49746
R3125 VSS.t113 VSS.n2288 8.49746
R3126 VSS.t114 VSS.n2299 8.49746
R3127 VSS.t114 VSS.n2297 8.49746
R3128 VSS.t114 VSS.n2292 8.49746
R3129 VSS.t114 VSS.n2290 8.49746
R3130 VSS.n2282 VSS.t149 8.49746
R3131 VSS.n2278 VSS.t149 8.49746
R3132 VSS.n2268 VSS.t149 8.49746
R3133 VSS.n2264 VSS.t149 8.49746
R3134 VSS.n2322 VSS.t148 8.49746
R3135 VSS.t142 VSS.n2169 8.49746
R3136 VSS.t142 VSS.n2164 8.49746
R3137 VSS.t142 VSS.n2162 8.49746
R3138 VSS.t142 VSS.n2143 8.49746
R3139 VSS.t61 VSS.n2140 8.49746
R3140 VSS.t61 VSS.n2130 8.49746
R3141 VSS.t61 VSS.n2126 8.49746
R3142 VSS.t143 VSS.n2154 8.49746
R3143 VSS.t143 VSS.n2152 8.49746
R3144 VSS.t143 VSS.n2147 8.49746
R3145 VSS.t143 VSS.n2145 8.49746
R3146 VSS.n2137 VSS.t62 8.49746
R3147 VSS.n2133 VSS.t62 8.49746
R3148 VSS.n2123 VSS.t62 8.49746
R3149 VSS.n2119 VSS.t62 8.49746
R3150 VSS.n2177 VSS.t61 8.49746
R3151 VSS.n2831 VSS.n647 8.49674
R3152 VSS.n2791 VSS.n647 8.49674
R3153 VSS.t106 VSS.n2812 8.49662
R3154 VSS.n1244 VSS.n1243 8.49469
R3155 VSS.n1246 VSS.n1245 8.49469
R3156 VSS.n1248 VSS.n1247 8.49469
R3157 VSS.n1250 VSS.n1249 8.49469
R3158 VSS.n1252 VSS.n1251 8.49469
R3159 VSS.n1254 VSS.n1253 8.49469
R3160 VSS.n1256 VSS.n1255 8.49469
R3161 VSS.t98 VSS.n2651 8.49143
R3162 VSS.t98 VSS.n2653 8.49143
R3163 VSS.t98 VSS.n2655 8.49143
R3164 VSS.t98 VSS.n2656 8.49143
R3165 VSS.t98 VSS.n2657 8.49143
R3166 VSS.t98 VSS.n2658 8.49143
R3167 VSS.t98 VSS.n2660 8.49143
R3168 VSS.t98 VSS.n2662 8.49143
R3169 VSS.n2663 VSS.t98 8.49143
R3170 VSS.t98 VSS.n2637 8.49143
R3171 VSS.t99 VSS.n2639 8.49143
R3172 VSS.t99 VSS.n2640 8.49143
R3173 VSS.t99 VSS.n2641 8.49143
R3174 VSS.t99 VSS.n2642 8.49143
R3175 VSS.t99 VSS.n2644 8.49143
R3176 VSS.t99 VSS.n2646 8.49143
R3177 VSS.t99 VSS.n2647 8.49143
R3178 VSS.t99 VSS.n2648 8.49143
R3179 VSS.t99 VSS.n2649 8.49143
R3180 VSS.t99 VSS.n2664 8.49143
R3181 VSS.t65 VSS.n2613 8.49143
R3182 VSS.t65 VSS.n2626 8.49143
R3183 VSS.t65 VSS.n2627 8.49143
R3184 VSS.t65 VSS.n2628 8.49143
R3185 VSS.t65 VSS.n2629 8.49143
R3186 VSS.t65 VSS.n2631 8.49143
R3187 VSS.t65 VSS.n2633 8.49143
R3188 VSS.t65 VSS.n2634 8.49143
R3189 VSS.n2635 VSS.t65 8.49143
R3190 VSS.t66 VSS.n2614 8.49143
R3191 VSS.t66 VSS.n2615 8.49143
R3192 VSS.t66 VSS.n2617 8.49143
R3193 VSS.t66 VSS.n2619 8.49143
R3194 VSS.t66 VSS.n2620 8.49143
R3195 VSS.t66 VSS.n2621 8.49143
R3196 VSS.t66 VSS.n2622 8.49143
R3197 VSS.t66 VSS.n2624 8.49143
R3198 VSS.t118 VSS.n2553 8.49143
R3199 VSS.t136 VSS.n2579 8.49143
R3200 VSS.t136 VSS.n2580 8.49143
R3201 VSS.t136 VSS.n2581 8.49143
R3202 VSS.t136 VSS.n2582 8.49143
R3203 VSS.t136 VSS.n2584 8.49143
R3204 VSS.t136 VSS.n2586 8.49143
R3205 VSS.t136 VSS.n2587 8.49143
R3206 VSS.t136 VSS.n2588 8.49143
R3207 VSS.t136 VSS.n2589 8.49143
R3208 VSS.t136 VSS.n2604 8.49143
R3209 VSS.t135 VSS.n2591 8.49143
R3210 VSS.t135 VSS.n2593 8.49143
R3211 VSS.t135 VSS.n2595 8.49143
R3212 VSS.t135 VSS.n2596 8.49143
R3213 VSS.t135 VSS.n2597 8.49143
R3214 VSS.t135 VSS.n2598 8.49143
R3215 VSS.t135 VSS.n2600 8.49143
R3216 VSS.t135 VSS.n2602 8.49143
R3217 VSS.n2603 VSS.t135 8.49143
R3218 VSS.t135 VSS.n2577 8.49143
R3219 VSS.t118 VSS.n2566 8.49143
R3220 VSS.t118 VSS.n2567 8.49143
R3221 VSS.t118 VSS.n2568 8.49143
R3222 VSS.t118 VSS.n2569 8.49143
R3223 VSS.t118 VSS.n2571 8.49143
R3224 VSS.t118 VSS.n2573 8.49143
R3225 VSS.t118 VSS.n2574 8.49143
R3226 VSS.n2575 VSS.t118 8.49143
R3227 VSS.t119 VSS.n2554 8.49143
R3228 VSS.t119 VSS.n2555 8.49143
R3229 VSS.t119 VSS.n2557 8.49143
R3230 VSS.t119 VSS.n2559 8.49143
R3231 VSS.t119 VSS.n2560 8.49143
R3232 VSS.t119 VSS.n2561 8.49143
R3233 VSS.t119 VSS.n2562 8.49143
R3234 VSS.t119 VSS.n2564 8.49143
R3235 VSS.t18 VSS.n733 8.49139
R3236 VSS.t15 VSS.n727 8.49139
R3237 VSS.t13 VSS.n730 8.49139
R3238 VSS.t16 VSS.n728 8.49139
R3239 VSS.t98 VSS.n2652 8.49129
R3240 VSS.t98 VSS.n2654 8.49129
R3241 VSS.t98 VSS.n2659 8.49129
R3242 VSS.t98 VSS.n2661 8.49129
R3243 VSS.t99 VSS.n2638 8.49129
R3244 VSS.t99 VSS.n2643 8.49129
R3245 VSS.t99 VSS.n2645 8.49129
R3246 VSS.t99 VSS.n2650 8.49129
R3247 VSS.t65 VSS.n2625 8.49129
R3248 VSS.t65 VSS.n2630 8.49129
R3249 VSS.t65 VSS.n2632 8.49129
R3250 VSS.t66 VSS.n2616 8.49129
R3251 VSS.t66 VSS.n2618 8.49129
R3252 VSS.t66 VSS.n2623 8.49129
R3253 VSS.t118 VSS.n2565 8.49129
R3254 VSS.t136 VSS.n2583 8.49129
R3255 VSS.t136 VSS.n2585 8.49129
R3256 VSS.t136 VSS.n2590 8.49129
R3257 VSS.t136 VSS.n2578 8.49129
R3258 VSS.t135 VSS.n2592 8.49129
R3259 VSS.t135 VSS.n2594 8.49129
R3260 VSS.t135 VSS.n2599 8.49129
R3261 VSS.t135 VSS.n2601 8.49129
R3262 VSS.t118 VSS.n2570 8.49129
R3263 VSS.t118 VSS.n2572 8.49129
R3264 VSS.t119 VSS.n2556 8.49129
R3265 VSS.t119 VSS.n2558 8.49129
R3266 VSS.t119 VSS.n2563 8.49129
R3267 VSS.n2210 VSS.t38 8.49102
R3268 VSS.n2214 VSS.t38 8.49102
R3269 VSS.n2218 VSS.t38 8.49102
R3270 VSS.n2220 VSS.t38 8.49102
R3271 VSS.n2222 VSS.t38 8.49102
R3272 VSS.n2224 VSS.t38 8.49102
R3273 VSS.n2228 VSS.t38 8.49102
R3274 VSS.n2232 VSS.t38 8.49102
R3275 VSS.n2234 VSS.t38 8.49102
R3276 VSS.n2236 VSS.t38 8.49102
R3277 VSS.t39 VSS.n2198 8.49102
R3278 VSS.t39 VSS.n2199 8.49102
R3279 VSS.t39 VSS.n2200 8.49102
R3280 VSS.t39 VSS.n2201 8.49102
R3281 VSS.t39 VSS.n2203 8.49102
R3282 VSS.t39 VSS.n2205 8.49102
R3283 VSS.t39 VSS.n2206 8.49102
R3284 VSS.t39 VSS.n2207 8.49102
R3285 VSS.t39 VSS.n2208 8.49102
R3286 VSS.t39 VSS.n2197 8.49102
R3287 VSS.t40 VSS.n2235 8.49102
R3288 VSS.t40 VSS.n2231 8.49102
R3289 VSS.t40 VSS.n2229 8.49102
R3290 VSS.t40 VSS.n2227 8.49102
R3291 VSS.t40 VSS.n2225 8.49102
R3292 VSS.t40 VSS.n2221 8.49102
R3293 VSS.t40 VSS.n2217 8.49102
R3294 VSS.t40 VSS.n2215 8.49102
R3295 VSS.t40 VSS.n2213 8.49102
R3296 VSS.t40 VSS.n2211 8.49102
R3297 VSS.t36 VSS.n2242 8.49102
R3298 VSS.t36 VSS.n2196 8.49102
R3299 VSS.t36 VSS.n2195 8.49102
R3300 VSS.t36 VSS.n2193 8.49102
R3301 VSS.t36 VSS.n2191 8.49102
R3302 VSS.t36 VSS.n2190 8.49102
R3303 VSS.t36 VSS.n2189 8.49102
R3304 VSS.t36 VSS.n2188 8.49102
R3305 VSS.t36 VSS.n2186 8.49102
R3306 VSS.t36 VSS.n2184 8.49102
R3307 VSS.n2212 VSS.t38 8.49088
R3308 VSS.n2216 VSS.t38 8.49088
R3309 VSS.n2226 VSS.t38 8.49088
R3310 VSS.n2230 VSS.t38 8.49088
R3311 VSS.t39 VSS.n2202 8.49088
R3312 VSS.t39 VSS.n2204 8.49088
R3313 VSS.t39 VSS.n2209 8.49088
R3314 VSS.t39 VSS.n2183 8.49088
R3315 VSS.t40 VSS.n2233 8.49088
R3316 VSS.t40 VSS.n2223 8.49088
R3317 VSS.t40 VSS.n2219 8.49088
R3318 VSS.n2239 VSS.t40 8.49088
R3319 VSS.t36 VSS.n2194 8.49088
R3320 VSS.t36 VSS.n2192 8.49088
R3321 VSS.t36 VSS.n2187 8.49088
R3322 VSS.t36 VSS.n2185 8.49088
R3323 VSS.n1349 VSS.t24 8.48798
R3324 VSS.t24 VSS.n1345 8.48798
R3325 VSS.t11 VSS.n1336 8.48798
R3326 VSS.t11 VSS.n1337 8.48798
R3327 VSS.t11 VSS.n1338 8.48798
R3328 VSS.t11 VSS.n1335 8.48798
R3329 VSS.t11 VSS.n1350 8.48798
R3330 VSS.t24 VSS.n1344 8.48798
R3331 VSS.t24 VSS.n1334 8.48798
R3332 VSS.n1284 VSS.n474 8.48362
R3333 VSS.n2331 VSS.n2092 8.47359
R3334 VSS.n1918 VSS.n1916 8.46995
R3335 VSS.n1921 VSS.n1920 8.46995
R3336 VSS.n1923 VSS.n1922 8.46995
R3337 VSS.n1925 VSS.n1914 8.46995
R3338 VSS.n1928 VSS.n1927 8.46995
R3339 VSS.n1930 VSS.n1929 8.46995
R3340 VSS.n1932 VSS.n1912 8.46995
R3341 VSS.n1935 VSS.n1934 8.46995
R3342 VSS.n1937 VSS.n1936 8.46995
R3343 VSS.n1939 VSS.n1910 8.46995
R3344 VSS.n1943 VSS.n1942 8.46995
R3345 VSS.n1259 VSS.n450 8.46995
R3346 VSS.n1261 VSS.n1260 8.46995
R3347 VSS.n1263 VSS.n1262 8.46995
R3348 VSS.n1265 VSS.n1264 8.46995
R3349 VSS.n1267 VSS.n1266 8.46995
R3350 VSS.n1269 VSS.n1268 8.46995
R3351 VSS.n1273 VSS.n1272 8.46995
R3352 VSS.n1275 VSS.n1274 8.46995
R3353 VSS.n1277 VSS.n1276 8.46995
R3354 VSS.n1279 VSS.n1278 8.46995
R3355 VSS.n1281 VSS.n1280 8.46995
R3356 VSS.n1283 VSS.n1282 8.46995
R3357 VSS.n2682 VSS.n2681 8.46995
R3358 VSS.n2684 VSS.n2683 8.46995
R3359 VSS.n2686 VSS.n2685 8.46995
R3360 VSS.n2691 VSS.n2690 8.46995
R3361 VSS.n2693 VSS.n2692 8.46995
R3362 VSS.n2695 VSS.n2694 8.46995
R3363 VSS.n2697 VSS.n2696 8.46995
R3364 VSS.n2699 VSS.n2698 8.46995
R3365 VSS.n2701 VSS.n2700 8.46995
R3366 VSS.n2703 VSS.n2702 8.46995
R3367 VSS.n2705 VSS.n2704 8.46995
R3368 VSS.n2707 VSS.n2706 8.46995
R3369 VSS.n2709 VSS.n2708 8.46995
R3370 VSS.n2711 VSS.n2710 8.46995
R3371 VSS.n2713 VSS.n2712 8.46995
R3372 VSS.n2715 VSS.n2714 8.46995
R3373 VSS.n2717 VSS.n2716 8.46995
R3374 VSS.n2719 VSS.n2718 8.46995
R3375 VSS.n2721 VSS.n2720 8.46995
R3376 VSS.n2723 VSS.n2722 8.46995
R3377 VSS.n2725 VSS.n2724 8.46995
R3378 VSS.n2727 VSS.n2726 8.46995
R3379 VSS.n2729 VSS.n2728 8.46995
R3380 VSS.n2733 VSS.n2732 8.46995
R3381 VSS.n2735 VSS.n2734 8.46995
R3382 VSS.n2737 VSS.n2736 8.46995
R3383 VSS.n2739 VSS.n2738 8.46995
R3384 VSS.n2742 VSS.n2741 8.46995
R3385 VSS.n2778 VSS.n2405 8.46995
R3386 VSS.n2777 VSS.n2406 8.46995
R3387 VSS.n2776 VSS.n2407 8.46995
R3388 VSS.n2775 VSS.n2408 8.46995
R3389 VSS.n2774 VSS.n2409 8.46995
R3390 VSS.n2773 VSS.n2410 8.46995
R3391 VSS.n2772 VSS.n2411 8.46995
R3392 VSS.n2771 VSS.n2412 8.46995
R3393 VSS.n2770 VSS.n2413 8.46995
R3394 VSS.n2769 VSS.n2414 8.46995
R3395 VSS.n2768 VSS.n2415 8.46995
R3396 VSS.n2767 VSS.n2416 8.46995
R3397 VSS.n2766 VSS.n2417 8.46995
R3398 VSS.n2765 VSS.n2418 8.46995
R3399 VSS.n2764 VSS.n2419 8.46995
R3400 VSS.n2763 VSS.n2420 8.46995
R3401 VSS.n2762 VSS.n2421 8.46995
R3402 VSS.n1113 VSS.n1053 8.46995
R3403 VSS.n1112 VSS.n1054 8.46995
R3404 VSS.n1111 VSS.n1055 8.46995
R3405 VSS.n1110 VSS.n1056 8.46995
R3406 VSS.n1109 VSS.n1057 8.46995
R3407 VSS.n1108 VSS.n1058 8.46995
R3408 VSS.n1107 VSS.n1059 8.46995
R3409 VSS.n1106 VSS.n1060 8.46995
R3410 VSS.n1105 VSS.n1061 8.46995
R3411 VSS.n1104 VSS.n1062 8.46995
R3412 VSS.n1103 VSS.n1063 8.46995
R3413 VSS.n1102 VSS.n1064 8.46995
R3414 VSS.n1101 VSS.n1065 8.46995
R3415 VSS.n1100 VSS.n1066 8.46995
R3416 VSS.n1099 VSS.n1067 8.46995
R3417 VSS.n1098 VSS.n1068 8.46995
R3418 VSS.n1097 VSS.n1069 8.46995
R3419 VSS.n1096 VSS.n1070 8.46995
R3420 VSS.n1095 VSS.n1071 8.46995
R3421 VSS.n1094 VSS.n1072 8.46995
R3422 VSS.n1093 VSS.n1073 8.46995
R3423 VSS.n1092 VSS.n1074 8.46995
R3424 VSS.n1091 VSS.n1075 8.46995
R3425 VSS.n1090 VSS.n1076 8.46995
R3426 VSS.n1087 VSS.n1078 8.46995
R3427 VSS.n1086 VSS.n1079 8.46995
R3428 VSS.n1085 VSS.n1080 8.46995
R3429 VSS.n1084 VSS.n1081 8.46995
R3430 VSS.n1083 VSS.n1082 8.46995
R3431 VSS.n2905 VSS.n590 8.46995
R3432 VSS.n2904 VSS.n591 8.46995
R3433 VSS.n2903 VSS.n592 8.46995
R3434 VSS.n2902 VSS.n593 8.46995
R3435 VSS.n2901 VSS.n594 8.46995
R3436 VSS.n2900 VSS.n595 8.46995
R3437 VSS.n2899 VSS.n596 8.46995
R3438 VSS.n2898 VSS.n597 8.46995
R3439 VSS.n2897 VSS.n598 8.46995
R3440 VSS.n2896 VSS.n599 8.46995
R3441 VSS.n2895 VSS.n600 8.46995
R3442 VSS.n2894 VSS.n601 8.46995
R3443 VSS.n2893 VSS.n602 8.46995
R3444 VSS.n2892 VSS.n603 8.46995
R3445 VSS.n2891 VSS.n604 8.46995
R3446 VSS.n1863 VSS.n1833 8.46995
R3447 VSS.n1865 VSS.n1864 8.46995
R3448 VSS.n1867 VSS.n1866 8.46995
R3449 VSS.n1869 VSS.n1868 8.46995
R3450 VSS.n1871 VSS.n1870 8.46995
R3451 VSS.n1873 VSS.n1872 8.46995
R3452 VSS.n1875 VSS.n1874 8.46995
R3453 VSS.n1877 VSS.n1876 8.46995
R3454 VSS.n1879 VSS.n1878 8.46995
R3455 VSS.n1883 VSS.n1882 8.46995
R3456 VSS.n1885 VSS.n1884 8.46995
R3457 VSS.n1887 VSS.n1886 8.46995
R3458 VSS.n1889 VSS.n1888 8.46995
R3459 VSS.n1891 VSS.n1890 8.46995
R3460 VSS.n1893 VSS.n1892 8.46995
R3461 VSS.n1895 VSS.n1894 8.46995
R3462 VSS.n1897 VSS.n1896 8.46995
R3463 VSS.n1899 VSS.n1898 8.46995
R3464 VSS.n2370 VSS.n2369 8.46995
R3465 VSS.n2372 VSS.n2371 8.46995
R3466 VSS.n2374 VSS.n2373 8.46995
R3467 VSS.n2376 VSS.n2375 8.46995
R3468 VSS.n2381 VSS.n2380 8.46995
R3469 VSS.n2383 VSS.n2382 8.46995
R3470 VSS.n2389 VSS.n2388 8.46995
R3471 VSS.n2391 VSS.n2390 8.46995
R3472 VSS.n2393 VSS.n2392 8.46995
R3473 VSS.n2395 VSS.n2394 8.46995
R3474 VSS.n2400 VSS.n2399 8.46995
R3475 VSS.n2402 VSS.n2401 8.46995
R3476 VSS.n2960 VSS.n7 8.46995
R3477 VSS.n2959 VSS.n8 8.46995
R3478 VSS.n2958 VSS.n9 8.46995
R3479 VSS.n2957 VSS.n10 8.46995
R3480 VSS.n2956 VSS.n11 8.46995
R3481 VSS.n2954 VSS.n13 8.46995
R3482 VSS.n2953 VSS.n14 8.46995
R3483 VSS.n2952 VSS.n15 8.46995
R3484 VSS.n2951 VSS.n16 8.46995
R3485 VSS.n2950 VSS.n17 8.46995
R3486 VSS.n2949 VSS.n18 8.46995
R3487 VSS.n2948 VSS.n19 8.46995
R3488 VSS.n2947 VSS.n20 8.46995
R3489 VSS.n2946 VSS.n21 8.46995
R3490 VSS.n2945 VSS.n22 8.46995
R3491 VSS.n2944 VSS.n23 8.46995
R3492 VSS.n2943 VSS.n24 8.46995
R3493 VSS.n2942 VSS.n25 8.46995
R3494 VSS.n2941 VSS.n26 8.46995
R3495 VSS.n2940 VSS.n27 8.46995
R3496 VSS.n2939 VSS.n28 8.46995
R3497 VSS.n2938 VSS.n29 8.46995
R3498 VSS.n2937 VSS.n30 8.46995
R3499 VSS.n2936 VSS.n31 8.46995
R3500 VSS.n2935 VSS.n32 8.46995
R3501 VSS.n2675 VSS.n36 8.46995
R3502 VSS.n2677 VSS.n2676 8.46995
R3503 VSS.n2679 VSS.n2678 8.46995
R3504 VSS.n1588 VSS.n474 8.46995
R3505 VSS.n1881 VSS.n1880 8.46086
R3506 VSS.n2731 VSS.n2730 8.45723
R3507 VSS.n2955 VSS.n12 8.45723
R3508 VSS.n1089 VSS.n1077 8.44997
R3509 VSS.n1271 VSS.n1270 8.44635
R3510 VSS.t108 VSS.n172 8.35705
R3511 VSS.n311 VSS.t23 8.35705
R3512 VSS.n321 VSS.t10 8.35705
R3513 VSS.t53 VSS.n84 8.35705
R3514 VSS.t1 VSS.n702 8.31075
R3515 VSS.t1 VSS.n653 8.31075
R3516 VSS.n2248 VSS.t35 8.31075
R3517 VSS.n2876 VSS.n474 8.03875
R3518 VSS.n1901 VSS.n1858 7.93093
R3519 VSS.n2387 VSS.n2386 7.84057
R3520 VSS.t35 VSS.n2000 7.82191
R3521 VSS.n2112 VSS.t37 7.82191
R3522 VSS.n900 VSS.n454 7.74
R3523 VSS.n473 VSS.n455 7.74
R3524 VSS.n1120 VSS.n665 7.57749
R3525 VSS.n1122 VSS.n677 7.57749
R3526 VSS.n1124 VSS.n664 7.57749
R3527 VSS.n1010 VSS.n678 7.57749
R3528 VSS.n1126 VSS.n663 7.57749
R3529 VSS.n1128 VSS.n679 7.57749
R3530 VSS.t43 VSS.n1296 7.5005
R3531 VSS.t43 VSS.n1297 7.5005
R3532 VSS.t43 VSS.n1298 7.5005
R3533 VSS.t43 VSS.n1299 7.5005
R3534 VSS.t43 VSS.n1467 7.5005
R3535 VSS.t43 VSS.n1463 7.5005
R3536 VSS.t43 VSS.n1405 7.5005
R3537 VSS.t43 VSS.n1400 7.5005
R3538 VSS.t49 VSS.n1183 7.5005
R3539 VSS.t49 VSS.n1172 7.5005
R3540 VSS.t49 VSS.n1190 7.5005
R3541 VSS.t49 VSS.n1171 7.5005
R3542 VSS.t49 VSS.n1197 7.5005
R3543 VSS.t49 VSS.n1170 7.5005
R3544 VSS.t49 VSS.n1204 7.5005
R3545 VSS.t49 VSS.n1169 7.5005
R3546 VSS.t49 VSS.n1211 7.5005
R3547 VSS.t49 VSS.n1168 7.5005
R3548 VSS.t49 VSS.n1218 7.5005
R3549 VSS.t49 VSS.n998 7.5005
R3550 VSS.t49 VSS.n999 7.5005
R3551 VSS.t127 VSS.n878 7.5005
R3552 VSS.t127 VSS.n877 7.5005
R3553 VSS.t127 VSS.n879 7.5005
R3554 VSS.t127 VSS.n876 7.5005
R3555 VSS.t127 VSS.n880 7.5005
R3556 VSS.t127 VSS.n875 7.5005
R3557 VSS.t127 VSS.n881 7.5005
R3558 VSS.t127 VSS.n874 7.5005
R3559 VSS.t127 VSS.n882 7.5005
R3560 VSS.t127 VSS.n873 7.5005
R3561 VSS.t127 VSS.n883 7.5005
R3562 VSS.n885 VSS.t127 7.5005
R3563 VSS.t127 VSS.n884 7.5005
R3564 VSS.t43 VSS.n1329 7.49994
R3565 VSS.t43 VSS.n1512 7.49985
R3566 VSS.n2782 VSS.t131 7.48911
R3567 VSS.n1121 VSS.n664 7.33307
R3568 VSS.n1009 VSS.n663 7.33307
R3569 VSS.n1125 VSS.n679 7.33307
R3570 VSS.n1127 VSS.n662 7.33307
R3571 VSS.n682 VSS.n680 7.33307
R3572 VSS.n681 VSS.n661 7.33307
R3573 VSS.n2116 VSS.n1993 7.33307
R3574 VSS.n2115 VSS.n1992 7.33307
R3575 VSS.n2113 VSS.n1990 7.33307
R3576 VSS.n2112 VSS.n1989 7.33307
R3577 VSS.n2111 VSS.n1988 7.33307
R3578 VSS.n2110 VSS.n1987 7.33307
R3579 VSS.n2109 VSS.n1986 7.33307
R3580 VSS.n2108 VSS.n1985 7.33307
R3581 VSS.n2106 VSS.n1983 7.33307
R3582 VSS.n2105 VSS.n1982 7.33307
R3583 VSS.n2104 VSS.n1981 7.33307
R3584 VSS.t60 VSS.n1980 7.33307
R3585 VSS.n2103 VSS.n1979 7.33307
R3586 VSS.n2102 VSS.n1978 7.33307
R3587 VSS.n2100 VSS.n1976 7.33307
R3588 VSS.n2099 VSS.n1975 7.33307
R3589 VSS.n1905 VSS.n1841 6.99306
R3590 VSS.n2326 VSS.t189 6.7784
R3591 VSS.n867 VSS.n853 6.40733
R3592 VSS.n683 VSS.n660 6.3554
R3593 VSS.n686 VSS.n685 6.3554
R3594 VSS.n689 VSS.n687 6.3554
R3595 VSS.n688 VSS.n658 6.3554
R3596 VSS.n691 VSS.n690 6.3554
R3597 VSS.n695 VSS.n692 6.3554
R3598 VSS.n693 VSS.n656 6.3554
R3599 VSS.n697 VSS.n696 6.3554
R3600 VSS.t1 VSS.n655 6.3554
R3601 VSS.n700 VSS.n698 6.3554
R3602 VSS.n699 VSS.n654 6.3554
R3603 VSS.n702 VSS.n701 6.3554
R3604 VSS.n703 VSS.n653 6.3554
R3605 VSS.n705 VSS.n704 6.3554
R3606 VSS.n706 VSS.n652 6.3554
R3607 VSS.n2878 VSS.t1 6.3554
R3608 VSS.t17 VSS.n678 5.86656
R3609 VSS.t80 VSS.n2012 5.86656
R3610 VSS.t182 VSS.n2006 5.86656
R3611 VSS.t171 VSS.n1999 5.86656
R3612 VSS.t178 VSS.n1991 5.86656
R3613 VSS.t180 VSS.n1984 5.86656
R3614 VSS.t121 VSS.n1977 5.86656
R3615 VSS.n931 VSS.n930 5.66778
R3616 VSS.n2919 VSS.n448 5.66778
R3617 VSS.n2920 VSS.n435 5.66778
R3618 VSS.n1117 VSS.n671 5.66778
R3619 VSS.n1131 VSS.n645 5.66778
R3620 VSS.n1607 VSS.n1606 5.66778
R3621 VSS.n1907 VSS.n1906 5.66778
R3622 VSS.n209 VSS.n208 5.66767
R3623 VSS.n932 VSS.n931 5.66767
R3624 VSS.n2919 VSS.n2918 5.66767
R3625 VSS.n2920 VSS.n73 5.66767
R3626 VSS.n253 VSS.n71 5.66767
R3627 VSS.n2922 VSS.n2921 5.66767
R3628 VSS.n2751 VSS.n2750 5.66767
R3629 VSS.n1117 VSS.n1116 5.66767
R3630 VSS.n1143 VSS.n645 5.66767
R3631 VSS.n2881 VSS.n501 5.66767
R3632 VSS.n1607 VSS.n722 5.66767
R3633 VSS.t95 VSS.n1561 5.66717
R3634 VSS.t95 VSS.n1562 5.66717
R3635 VSS.t33 VSS.n229 5.66717
R3636 VSS.t33 VSS.n228 5.66717
R3637 VSS.t33 VSS.n227 5.66717
R3638 VSS.t33 VSS.n226 5.66717
R3639 VSS.t33 VSS.n225 5.66717
R3640 VSS.t33 VSS.n224 5.66717
R3641 VSS.t33 VSS.n223 5.66717
R3642 VSS.t33 VSS.n222 5.66717
R3643 VSS.t33 VSS.n221 5.66717
R3644 VSS.t33 VSS.n207 5.66717
R3645 VSS.n230 VSS.t33 5.66717
R3646 VSS.n608 VSS.t50 5.66717
R3647 VSS.n608 VSS.t151 5.66717
R3648 VSS.n837 VSS.t130 5.66717
R3649 VSS.n837 VSS.t146 5.66717
R3650 VSS.n2923 VSS.n366 5.66642
R3651 VSS.n2923 VSS.n235 5.66642
R3652 VSS.n2907 VSS.n2906 5.62809
R3653 VSS.n694 VSS.n693 5.62214
R3654 VSS.n2331 VSS.n2094 5.61923
R3655 VSS.n492 VSS.n475 5.61281
R3656 VSS.n2504 VSS.n647 5.61281
R3657 VSS.t25 VSS.n1802 5.37772
R3658 VSS.t185 VSS.n1805 5.1333
R3659 VSS.n1909 VSS.n1908 5.09586
R3660 VSS.n2838 VSS.t105 5.03912
R3661 VSS.n2509 VSS.t115 5.02687
R3662 VSS.n2505 VSS.t78 5.01873
R3663 VSS.t92 VSS.n176 5.01443
R3664 VSS.t56 VSS.n80 5.01443
R3665 VSS.t185 VSS.t161 4.88888
R3666 VSS.n1947 VSS.n1946 4.84817
R3667 VSS.n695 VSS.n694 4.64446
R3668 VSS.n474 VSS.n473 4.6315
R3669 VSS.n2917 VSS.n454 4.6315
R3670 VSS.n463 VSS.n68 4.5966
R3671 VSS.n2747 VSS.n670 4.40004
R3672 VSS.n2881 VSS.n2880 4.40004
R3673 VSS.n673 VSS.n672 4.40004
R3674 VSS.n1012 VSS.n668 4.40004
R3675 VSS.n1014 VSS.n674 4.40004
R3676 VSS.n1016 VSS.n667 4.40004
R3677 VSS.n1018 VSS.n675 4.40004
R3678 VSS.n1020 VSS.n666 4.40004
R3679 VSS.n1022 VSS.n676 4.40004
R3680 VSS.t1 VSS.n657 4.40004
R3681 VSS.t185 VSS.n1849 4.40004
R3682 VSS.t161 VSS.n1844 4.40004
R3683 VSS.t162 VSS.n1339 4.25206
R3684 VSS.t163 VSS.n1339 4.25175
R3685 VSS.n2874 VSS.n2873 4.251
R3686 VSS.t33 VSS.n210 4.24791
R3687 VSS.n2478 VSS.t116 4.24754
R3688 VSS.n1234 VSS.n499 4.24696
R3689 VSS.n2872 VSS.n1973 4.24467
R3690 VSS.n670 VSS.n669 4.20397
R3691 VSS.n669 VSS.n615 4.20347
R3692 VSS.n2917 VSS.n472 4.18441
R3693 VSS.n2331 VSS.n2098 4.18322
R3694 VSS.t4 VSS.n677 4.15562
R3695 VSS.t185 VSS.n1798 4.15562
R3696 VSS.n1840 VSS.n1804 4.15562
R3697 VSS.n1847 VSS.n1805 4.15562
R3698 VSS.n1859 VSS.n1806 4.15562
R3699 VSS.n1846 VSS.n1807 4.15562
R3700 VSS.t185 VSS.n1808 4.15562
R3701 VSS.n1845 VSS.n1809 4.15562
R3702 VSS.n1842 VSS.n1810 4.15562
R3703 VSS.n1844 VSS.n1811 4.15562
R3704 VSS.n1843 VSS.n1812 4.15562
R3705 VSS.n493 VSS.t20 3.98408
R3706 VSS.n1607 VSS.t46 3.91121
R3707 VSS.t1 VSS.n2877 3.91121
R3708 VSS.n482 VSS.n462 3.76095
R3709 VSS.n483 VSS.n461 3.76095
R3710 VSS.n484 VSS.n460 3.76095
R3711 VSS.n485 VSS.n459 3.76095
R3712 VSS.n486 VSS.n458 3.76095
R3713 VSS.n488 VSS.n457 3.76095
R3714 VSS.n489 VSS.n456 3.76095
R3715 VSS.n491 VSS.n455 3.76095
R3716 VSS.n1908 VSS.n1907 3.73684
R3717 VSS.t9 VSS.n1795 3.66679
R3718 VSS.t65 VSS.n2612 3.4022
R3719 VSS.t118 VSS.n2552 3.4022
R3720 VSS.t66 VSS.n2612 3.40192
R3721 VSS.t119 VSS.n2552 3.40192
R3722 VSS.n2926 VSS.n72 3.39841
R3723 VSS.n1573 VSS.n70 3.39835
R3724 VSS.n2913 VSS.n2912 3.37639
R3725 VSS.n1353 VSS.n234 3.35321
R3726 VSS.t68 VSS.n155 3.34312
R3727 VSS.t138 VSS.n103 3.34312
R3728 VSS.t19 VSS.n463 3.34312
R3729 VSS.t64 VSS.n2745 3.31206
R3730 VSS.n1355 VSS.n234 3.30365
R3731 VSS.n2841 VSS.n647 3.30365
R3732 VSS.n1119 VSS.t4 3.17795
R3733 VSS.t185 VSS.n1810 3.17795
R3734 VSS.n2075 VSS.n2074 3.163
R3735 VSS.n2076 VSS.n2075 3.163
R3736 VSS.n1859 VSS.n1841 3.01687
R3737 VSS.t185 VSS.n1841 3.01687
R3738 VSS.n2367 VSS 3.00167
R3739 VSS.n1347 VSS.t22 3.00078
R3740 VSS.n1146 VSS.t74 2.83383
R3741 VSS.n1160 VSS.t73 2.83383
R3742 VSS.t33 VSS.n220 2.83156
R3743 VSS.t1 VSS.n1677 2.81085
R3744 VSS.n1591 VSS.n474 2.80993
R3745 VSS.n1321 VSS.t29 2.74076
R3746 VSS.n495 VSS.n475 2.71714
R3747 VSS.n494 VSS.n475 2.7042
R3748 VSS.n1114 VSS.n649 2.62007
R3749 VSS.n2075 VSS.t172 2.50803
R3750 VSS.n1900 VSS.n1862 2.4566
R3751 VSS.t46 VSS.n684 2.44469
R3752 VSS.t1 VSS.n659 2.44469
R3753 VSS.n1846 VSS.t34 2.44469
R3754 VSS.n1342 VSS 2.34249
R3755 VSS.n1905 VSS.n1835 2.29794
R3756 VSS.t185 VSS.n1803 2.20027
R3757 VSS.n2075 VSS.t173 2.18681
R3758 VSS.n669 VSS.n647 2.15027
R3759 VSS.n1226 VSS.n1225 2.14531
R3760 VSS.n2910 VSS.n497 2.14522
R3761 VSS.n1227 VSS.n1226 2.14494
R3762 VSS.n498 VSS.n497 2.14404
R3763 VSS.n901 VSS.n588 2.08964
R3764 VSS.n1333 VSS.n234 1.97148
R3765 VSS.t185 VSS.n1848 1.95585
R3766 VSS.n2331 VSS.n2325 1.88593
R3767 VSS.n2319 VSS.t111 1.87257
R3768 VSS.n2174 VSS.t59 1.87257
R3769 VSS VSS.n1341 1.84384
R3770 VSS.t21 VSS.n2672 1.72795
R3771 VSS.n2673 VSS.t21 1.72734
R3772 VSS.n2923 VSS.n306 1.72169
R3773 VSS.n2923 VSS.n319 1.72162
R3774 VSS.n2506 VSS.n647 1.71792
R3775 VSS.n1120 VSS.n1119 1.71143
R3776 VSS.n1122 VSS.n1121 1.71143
R3777 VSS.n1124 VSS.n1123 1.71143
R3778 VSS.n1010 VSS.n1009 1.71143
R3779 VSS.n1126 VSS.n1125 1.71143
R3780 VSS.n1128 VSS.n1127 1.71143
R3781 VSS.t41 VSS.n1799 1.71143
R3782 VSS.t23 VSS.n136 1.67181
R3783 VSS.t10 VSS.n120 1.67181
R3784 VSS.n1083 VSS.n648 1.60281
R3785 VSS.n304 VSS.t70 1.54595
R3786 VSS.n285 VSS.t69 1.54595
R3787 VSS.n283 VSS.t110 1.54595
R3788 VSS.n259 VSS.t109 1.54595
R3789 VSS.n360 VSS.t55 1.54595
R3790 VSS.n346 VSS.t54 1.54595
R3791 VSS.n342 VSS.t140 1.54595
R3792 VSS.n329 VSS.t139 1.54595
R3793 VSS.n1916 VSS.n1785 1.544
R3794 VSS.n1944 VSS.n1943 1.53377
R3795 VSS.n2503 VSS.n648 1.53024
R3796 VSS.n2779 VSS.n647 1.51762
R3797 VSS VSS.n1944 1.51716
R3798 VSS.n2741 VSS.n2740 1.51062
R3799 VSS.n2073 VSS.t120 1.49919
R3800 VSS.n2077 VSS.t79 1.49919
R3801 VSS.n492 VSS.n487 1.47281
R3802 VSS.n1123 VSS.t17 1.46701
R3803 VSS.n2114 VSS.t178 1.46701
R3804 VSS.t37 VSS.n1990 1.46701
R3805 VSS.n2107 VSS.t180 1.46701
R3806 VSS.n2101 VSS.t121 1.46701
R3807 VSS.n2329 VSS.n2328 1.4527
R3808 VSS.n2329 VSS.n2326 1.42867
R3809 VSS.n2913 VSS.n491 1.41717
R3810 VSS.n1166 VSS.n1008 1.41717
R3811 VSS.n2784 VSS.n2783 1.41495
R3812 VSS.n2091 VSS.n2089 1.40332
R3813 VSS.n2680 VSS.n2679 1.37662
R3814 VSS.n2682 VSS.n2680 1.36762
R3815 VSS.n2503 VSS.n649 1.36737
R3816 VSS.n2331 VSS.n2093 1.36304
R3817 VSS.n2509 VSS.n2508 1.35507
R3818 VSS.n2331 VSS.n2245 1.35404
R3819 VSS.n2783 VSS.n2782 1.34815
R3820 VSS.n1946 VSS.n1785 1.33464
R3821 VSS.n2839 VSS.n2838 1.33364
R3822 VSS.n2179 VSS.n2089 1.32908
R3823 VSS.n1595 VSS.n1594 1.30968
R3824 VSS.n2913 VSS.n449 1.30819
R3825 VSS.n2872 VSS.n2014 1.30486
R3826 VSS.n1114 VSS.n1113 1.29987
R3827 VSS.n1598 VSS.n1597 1.29765
R3828 VSS.n1599 VSS.n1598 1.27727
R3829 VSS.n1594 VSS.n1593 1.26538
R3830 VSS.n836 VSS.n504 1.25983
R3831 VSS.n2740 VSS.n2403 1.25023
R3832 VSS.n2979 VSS 1.23729
R3833 VSS.n2840 VSS.n2839 1.23664
R3834 VSS.n676 VSS.t72 1.2226
R3835 VSS.n2508 VSS.n2507 1.22242
R3836 VSS.n1900 VSS.n1899 1.20622
R3837 VSS.n589 VSS.n504 1.20038
R3838 VSS.n2674 VSS.n2673 1.16602
R3839 VSS.n2672 VSS.n33 1.16602
R3840 VSS.n1858 VSS.n1854 1.14113
R3841 VSS.n1858 VSS.t185 1.14113
R3842 VSS.n2961 VSS.n2960 1.139
R3843 VSS.n1862 VSS.n1861 1.11483
R3844 VSS.n2331 VSS.n2097 1.09883
R3845 VSS.n907 VSS.n587 1.08189
R3846 VSS.n2871 VSS 1.07217
R3847 VSS.n2980 VSS 1.06369
R3848 VSS.n926 VSS.n452 1.0635
R3849 VSS.n927 VSS.n499 1.06303
R3850 VSS.n1129 VSS.n1128 1.063
R3851 VSS VSS.n2980 1.03607
R3852 VSS.n2096 VSS.n1974 1.02294
R3853 VSS VSS.n1692 1.01967
R3854 VSS.n1145 VSS.n1129 1.01707
R3855 VSS.n2917 VSS.n468 0.998636
R3856 VSS.n1863 VSS.n1852 0.998019
R3857 VSS.n1677 VSS.n474 0.995094
R3858 VSS.n2872 VSS.n1996 0.969823
R3859 VSS.n1945 VSS.n1909 0.965747
R3860 VSS.n1603 VSS 0.96391
R3861 VSS.n1604 VSS.n1603 0.934041
R3862 VSS.t1 VSS.n2876 0.925508
R3863 VSS.n2911 VSS.n487 0.91374
R3864 VSS.n2968 VSS.n0 0.906314
R3865 VSS.n2978 VSS.n3 0.906275
R3866 VSS.n2971 VSS.n2967 0.9005
R3867 VSS.n2974 VSS.n2966 0.9005
R3868 VSS.n2975 VSS.n2965 0.9005
R3869 VSS.n2964 VSS.n4 0.9005
R3870 VSS.n2963 VSS.n3 0.9005
R3871 VSS.n2977 VSS.n4 0.9005
R3872 VSS.n2976 VSS.n2975 0.9005
R3873 VSS.n2974 VSS.n2973 0.9005
R3874 VSS.n2972 VSS.n2971 0.9005
R3875 VSS.n2970 VSS.n2969 0.9005
R3876 VSS.n2979 VSS.n0 0.9005
R3877 VSS.n2878 VSS.n647 0.895237
R3878 VSS.n990 VSS.n499 0.894919
R3879 VSS VSS.n1602 0.894288
R3880 VSS.n2962 VSS.n2961 0.870048
R3881 VSS.n1602 VSS.n1601 0.850891
R3882 VSS.n1572 VSS.t104 0.8505
R3883 VSS.t44 VSS.n1291 0.8505
R3884 VSS.t44 VSS.n1290 0.8505
R3885 VSS.t95 VSS.n1558 0.8505
R3886 VSS.t95 VSS.n1560 0.8505
R3887 VSS.n1563 VSS.t95 0.8505
R3888 VSS.n2096 VSS.n1996 0.828405
R3889 VSS.n1945 VSS 0.822288
R3890 VSS.n2331 VSS.n2180 0.819457
R3891 VSS.n2748 VSS.n647 0.804017
R3892 VSS.n1602 VSS.n474 0.799993
R3893 VSS.n1500 VSS.t77 0.774925
R3894 VSS.n1526 VSS.t76 0.774925
R3895 VSS.n1529 VSS.t96 0.774925
R3896 VSS.t44 VSS.n1570 0.774899
R3897 VSS.t90 VSS.n178 0.77385
R3898 VSS.n77 VSS.t58 0.773227
R3899 VSS.n1395 VSS.t57 0.773227
R3900 VSS.t57 VSS.n1393 0.773227
R3901 VSS.t57 VSS.n1394 0.773227
R3902 VSS.n1361 VSS.t85 0.773227
R3903 VSS.n1321 VSS.t84 0.773227
R3904 VSS.n1320 VSS.t91 0.773227
R3905 VSS.n1303 VSS.t90 0.773227
R3906 VSS.t90 VSS.n1302 0.773227
R3907 VSS.n1852 VSS.n1851 0.757658
R3908 VSS.n6 VSS.n5 0.752901
R3909 VSS.n672 VSS.n645 0.733757
R3910 VSS.n1013 VSS.n1012 0.733757
R3911 VSS.n1015 VSS.n1014 0.733757
R3912 VSS.n1017 VSS.n1016 0.733757
R3913 VSS.n1019 VSS.t12 0.733757
R3914 VSS.n1019 VSS.n1018 0.733757
R3915 VSS.n1021 VSS.n1020 0.733757
R3916 VSS.n1023 VSS.n1022 0.733757
R3917 VSS.n1903 VSS.n1786 0.733757
R3918 VSS.n1834 VSS.n1793 0.733757
R3919 VSS.n1855 VSS.n1794 0.733757
R3920 VSS.n1836 VSS.n1795 0.733757
R3921 VSS.n1854 VSS.n1796 0.733757
R3922 VSS.n1837 VSS.n1797 0.733757
R3923 VSS.n1853 VSS.n1798 0.733757
R3924 VSS.n1850 VSS.n1799 0.733757
R3925 VSS.n1838 VSS.n1800 0.733757
R3926 VSS.n1849 VSS.n1801 0.733757
R3927 VSS.n1839 VSS.n1802 0.733757
R3928 VSS.n1905 VSS.n1852 0.7287
R3929 VSS.n1603 VSS.n474 0.721922
R3930 VSS.n2327 VSS.n1996 0.7195
R3931 VSS.n1946 VSS.n1945 0.712717
R3932 VSS.n2315 VSS.n2097 0.709635
R3933 VSS.n1589 VSS 0.708167
R3934 VSS.n2097 VSS.n2096 0.705845
R3935 VSS.n2244 VSS.n2180 0.687614
R3936 VSS.n2779 VSS.n2778 0.671837
R3937 VSS.n2879 VSS.n2878 0.654346
R3938 VSS.n1563 VSS.n182 0.645872
R3939 VSS.n2368 VSS.n5 0.638681
R3940 VSS.t175 VSS.n2384 0.635213
R3941 VSS.t176 VSS.n2384 0.63516
R3942 VSS.n1352 VSS 0.603667
R3943 VSS.n2507 VSS.n2506 0.600114
R3944 VSS VSS.n2093 0.59889
R3945 VSS.n2666 VSS.t160 0.592115
R3946 VSS.n2606 VSS.t48 0.592115
R3947 VSS.n2666 VSS.t159 0.592068
R3948 VSS.n2606 VSS.t47 0.592068
R3949 VSS.n1592 VSS.n474 0.585865
R3950 VSS.n2926 VSS.n178 0.579298
R3951 VSS.n1354 VSS.n319 0.57067
R3952 VSS.n1332 VSS.n306 0.570236
R3953 VSS.n2673 VSS.n2611 0.563
R3954 VSS.n2672 VSS.n2671 0.563
R3955 VSS.n2324 VSS.n2245 0.56102
R3956 VSS.n2961 VSS.n6 0.547495
R3957 VSS.n2170 VSS.n2093 0.543805
R3958 VSS.n2780 VSS.n2779 0.525489
R3959 VSS.n1333 VSS.n1332 0.519488
R3960 VSS.n2872 VSS.n1974 0.513933
R3961 VSS.n2506 VSS.n2505 0.508111
R3962 VSS.n1352 VSS.n1333 0.492937
R3963 VSS.n2330 VSS.n2013 0.489338
R3964 VSS.n2333 VSS.n2087 0.489338
R3965 VSS.n2332 VSS.n2012 0.489338
R3966 VSS.n2261 VSS.n2086 0.489338
R3967 VSS.n2260 VSS.n2011 0.489338
R3968 VSS.n2259 VSS.n2085 0.489338
R3969 VSS.n2258 VSS.t112 0.489338
R3970 VSS.n2257 VSS.n2008 0.489338
R3971 VSS.n2256 VSS.n2007 0.489338
R3972 VSS.n2255 VSS.n2006 0.489338
R3973 VSS.n2254 VSS.n2005 0.489338
R3974 VSS.n2253 VSS.n2004 0.489338
R3975 VSS.n2252 VSS.n2003 0.489338
R3976 VSS.n2251 VSS.n2002 0.489338
R3977 VSS.n2250 VSS.n2001 0.489338
R3978 VSS.n2249 VSS.n2000 0.489338
R3979 VSS.n2248 VSS.n1999 0.489338
R3980 VSS.n2247 VSS.n1998 0.489338
R3981 VSS.n2246 VSS.n1997 0.489338
R3982 VSS.n2182 VSS.n1995 0.489338
R3983 VSS.n1848 VSS.t174 0.489338
R3984 VSS.n1857 VSS.n1809 0.489338
R3985 VSS.n2872 VSS.n1692 0.464817
R3986 VSS.n2968 VSS.n2967 0.464756
R3987 VSS.n2872 VSS.n2871 0.464147
R3988 VSS.n1596 VSS.n474 0.452728
R3989 VSS.n2245 VSS.n2244 0.452285
R3990 VSS.n2979 VSS.n2978 0.448362
R3991 VSS.n2979 VSS.n2 0.448362
R3992 VSS.n2979 VSS.n1 0.448362
R3993 VSS.n1600 VSS.n474 0.437138
R3994 VSS.n1903 VSS.n1902 0.436897
R3995 VSS.n494 VSS.n493 0.431611
R3996 VSS.n1342 VSS.n306 0.43068
R3997 VSS.n1342 VSS.n319 0.43024
R3998 VSS.n1851 VSS.n1835 0.419509
R3999 VSS.n2912 VSS.n495 0.398763
R4000 VSS VSS.n494 0.396409
R4001 VSS.n2874 VSS.n1678 0.391201
R4002 VSS.n1901 VSS.n1900 0.385689
R4003 VSS.n2090 VSS.n1974 0.381915
R4004 VSS.n495 VSS 0.381126
R4005 VSS.n2386 VSS.n2384 0.376377
R4006 VSS.n2841 VSS.n2840 0.372606
R4007 VSS.n1600 VSS.n1599 0.371993
R4008 VSS.n2871 VSS.n2870 0.370838
R4009 VSS.n1597 VSS.n1596 0.366039
R4010 VSS.n1596 VSS.n1595 0.363853
R4011 VSS.n2667 VSS.n2666 0.359899
R4012 VSS.n2607 VSS.n2606 0.359899
R4013 VSS.n1601 VSS.n1600 0.357894
R4014 VSS.n1860 VSS.n1692 0.357261
R4015 VSS.n1355 VSS.n1354 0.346939
R4016 VSS.n1259 VSS.n472 0.333834
R4017 VSS.n1356 VSS.n1355 0.332867
R4018 VSS.n1861 VSS.n1835 0.330463
R4019 VSS.n1593 VSS.n1592 0.318841
R4020 VSS.n1592 VSS 0.310077
R4021 VSS.n2180 VSS.n2179 0.302742
R4022 VSS.n1271 VSS.n1269 0.297565
R4023 VSS.n1273 VSS.n1271 0.297565
R4024 VSS.n1115 VSS.n1114 0.294076
R4025 VSS.n2842 VSS.n2841 0.292533
R4026 VSS.n1090 VSS.n1089 0.290323
R4027 VSS.n2906 VSS.n2905 0.289467
R4028 VSS.n1929 VSS.n1928 0.283378
R4029 VSS.n2840 VSS.n2403 0.279167
R4030 VSS.n2505 VSS.n2504 0.279086
R4031 VSS.n2731 VSS.n2729 0.275819
R4032 VSS.n2733 VSS.n2731 0.275819
R4033 VSS.n2955 VSS.n2954 0.275819
R4034 VSS.n2956 VSS.n2955 0.275819
R4035 VSS.n2507 VSS.n2503 0.27
R4036 VSS.n1883 VSS.n1881 0.268558
R4037 VSS.n1881 VSS.n1879 0.268558
R4038 VSS.n2879 VSS.n651 0.266125
R4039 VSS.n1587 VSS.n1586 0.2645
R4040 VSS.n681 VSS.n499 0.254231
R4041 VSS.n2778 VSS.n2777 0.250378
R4042 VSS.n2777 VSS.n2776 0.250378
R4043 VSS.n2776 VSS.n2775 0.250378
R4044 VSS.n2775 VSS.n2774 0.250378
R4045 VSS.n2774 VSS.n2773 0.250378
R4046 VSS.n2773 VSS.n2772 0.250378
R4047 VSS.n2772 VSS.n2771 0.250378
R4048 VSS.n2771 VSS.n2770 0.250378
R4049 VSS.n2770 VSS.n2769 0.250378
R4050 VSS.n2769 VSS.n2768 0.250378
R4051 VSS.n2768 VSS.n2767 0.250378
R4052 VSS.n2767 VSS.n2766 0.250378
R4053 VSS.n2766 VSS.n2765 0.250378
R4054 VSS.n2765 VSS.n2764 0.250378
R4055 VSS.n2764 VSS.n2763 0.250378
R4056 VSS.n2763 VSS.n2762 0.250378
R4057 VSS.n2684 VSS.n2682 0.250378
R4058 VSS.n2686 VSS.n2684 0.250378
R4059 VSS.n2693 VSS.n2691 0.250378
R4060 VSS.n2695 VSS.n2693 0.250378
R4061 VSS.n2697 VSS.n2695 0.250378
R4062 VSS.n2699 VSS.n2697 0.250378
R4063 VSS.n2701 VSS.n2699 0.250378
R4064 VSS.n2703 VSS.n2701 0.250378
R4065 VSS.n2705 VSS.n2703 0.250378
R4066 VSS.n2707 VSS.n2705 0.250378
R4067 VSS.n2709 VSS.n2707 0.250378
R4068 VSS.n2711 VSS.n2709 0.250378
R4069 VSS.n2713 VSS.n2711 0.250378
R4070 VSS.n2715 VSS.n2713 0.250378
R4071 VSS.n2717 VSS.n2715 0.250378
R4072 VSS.n2719 VSS.n2717 0.250378
R4073 VSS.n2721 VSS.n2719 0.250378
R4074 VSS.n2723 VSS.n2721 0.250378
R4075 VSS.n2725 VSS.n2723 0.250378
R4076 VSS.n2727 VSS.n2725 0.250378
R4077 VSS.n2729 VSS.n2727 0.250378
R4078 VSS.n2735 VSS.n2733 0.250378
R4079 VSS.n2737 VSS.n2735 0.250378
R4080 VSS.n2739 VSS.n2737 0.250378
R4081 VSS.n2741 VSS.n2739 0.250378
R4082 VSS.n2679 VSS.n2677 0.250378
R4083 VSS.n2677 VSS.n2675 0.250378
R4084 VSS.n2936 VSS.n2935 0.250378
R4085 VSS.n2937 VSS.n2936 0.250378
R4086 VSS.n2938 VSS.n2937 0.250378
R4087 VSS.n2939 VSS.n2938 0.250378
R4088 VSS.n2940 VSS.n2939 0.250378
R4089 VSS.n2941 VSS.n2940 0.250378
R4090 VSS.n2942 VSS.n2941 0.250378
R4091 VSS.n2943 VSS.n2942 0.250378
R4092 VSS.n2944 VSS.n2943 0.250378
R4093 VSS.n2945 VSS.n2944 0.250378
R4094 VSS.n2946 VSS.n2945 0.250378
R4095 VSS.n2947 VSS.n2946 0.250378
R4096 VSS.n2948 VSS.n2947 0.250378
R4097 VSS.n2949 VSS.n2948 0.250378
R4098 VSS.n2950 VSS.n2949 0.250378
R4099 VSS.n2951 VSS.n2950 0.250378
R4100 VSS.n2952 VSS.n2951 0.250378
R4101 VSS.n2953 VSS.n2952 0.250378
R4102 VSS.n2954 VSS.n2953 0.250378
R4103 VSS.n2957 VSS.n2956 0.250378
R4104 VSS.n2958 VSS.n2957 0.250378
R4105 VSS.n2959 VSS.n2958 0.250378
R4106 VSS.n2960 VSS.n2959 0.250378
R4107 VSS.n1261 VSS.n1259 0.250378
R4108 VSS.n1263 VSS.n1261 0.250378
R4109 VSS.n1265 VSS.n1263 0.250378
R4110 VSS.n1267 VSS.n1265 0.250378
R4111 VSS.n1269 VSS.n1267 0.250378
R4112 VSS.n1275 VSS.n1273 0.250378
R4113 VSS.n1277 VSS.n1275 0.250378
R4114 VSS.n1279 VSS.n1277 0.250378
R4115 VSS.n1281 VSS.n1279 0.250378
R4116 VSS.n1283 VSS.n1281 0.250378
R4117 VSS.n2905 VSS.n2904 0.250378
R4118 VSS.n2904 VSS.n2903 0.250378
R4119 VSS.n2903 VSS.n2902 0.250378
R4120 VSS.n2902 VSS.n2901 0.250378
R4121 VSS.n2901 VSS.n2900 0.250378
R4122 VSS.n2900 VSS.n2899 0.250378
R4123 VSS.n2899 VSS.n2898 0.250378
R4124 VSS.n2898 VSS.n2897 0.250378
R4125 VSS.n2897 VSS.n2896 0.250378
R4126 VSS.n2896 VSS.n2895 0.250378
R4127 VSS.n2895 VSS.n2894 0.250378
R4128 VSS.n2894 VSS.n2893 0.250378
R4129 VSS.n2893 VSS.n2892 0.250378
R4130 VSS.n2892 VSS.n2891 0.250378
R4131 VSS.n1921 VSS.n1916 0.250378
R4132 VSS.n1922 VSS.n1921 0.250378
R4133 VSS.n1922 VSS.n1914 0.250378
R4134 VSS.n1928 VSS.n1914 0.250378
R4135 VSS.n1929 VSS.n1912 0.250378
R4136 VSS.n1935 VSS.n1912 0.250378
R4137 VSS.n1936 VSS.n1935 0.250378
R4138 VSS.n1936 VSS.n1910 0.250378
R4139 VSS.n1943 VSS.n1910 0.250378
R4140 VSS.n1113 VSS.n1112 0.250378
R4141 VSS.n1112 VSS.n1111 0.250378
R4142 VSS.n1111 VSS.n1110 0.250378
R4143 VSS.n1110 VSS.n1109 0.250378
R4144 VSS.n1109 VSS.n1108 0.250378
R4145 VSS.n1108 VSS.n1107 0.250378
R4146 VSS.n1107 VSS.n1106 0.250378
R4147 VSS.n1106 VSS.n1105 0.250378
R4148 VSS.n1105 VSS.n1104 0.250378
R4149 VSS.n1104 VSS.n1103 0.250378
R4150 VSS.n1103 VSS.n1102 0.250378
R4151 VSS.n1102 VSS.n1101 0.250378
R4152 VSS.n1101 VSS.n1100 0.250378
R4153 VSS.n1100 VSS.n1099 0.250378
R4154 VSS.n1099 VSS.n1098 0.250378
R4155 VSS.n1098 VSS.n1097 0.250378
R4156 VSS.n1097 VSS.n1096 0.250378
R4157 VSS.n1096 VSS.n1095 0.250378
R4158 VSS.n1095 VSS.n1094 0.250378
R4159 VSS.n1094 VSS.n1093 0.250378
R4160 VSS.n1093 VSS.n1092 0.250378
R4161 VSS.n1092 VSS.n1091 0.250378
R4162 VSS.n1091 VSS.n1090 0.250378
R4163 VSS.n1087 VSS.n1086 0.250378
R4164 VSS.n1086 VSS.n1085 0.250378
R4165 VSS.n1085 VSS.n1084 0.250378
R4166 VSS.n1084 VSS.n1083 0.250378
R4167 VSS.n1899 VSS.n1897 0.250378
R4168 VSS.n1897 VSS.n1895 0.250378
R4169 VSS.n1895 VSS.n1893 0.250378
R4170 VSS.n1893 VSS.n1891 0.250378
R4171 VSS.n1891 VSS.n1889 0.250378
R4172 VSS.n1889 VSS.n1887 0.250378
R4173 VSS.n1887 VSS.n1885 0.250378
R4174 VSS.n1885 VSS.n1883 0.250378
R4175 VSS.n1879 VSS.n1877 0.250378
R4176 VSS.n1877 VSS.n1875 0.250378
R4177 VSS.n1875 VSS.n1873 0.250378
R4178 VSS.n1873 VSS.n1871 0.250378
R4179 VSS.n1871 VSS.n1869 0.250378
R4180 VSS.n1869 VSS.n1867 0.250378
R4181 VSS.n1867 VSS.n1865 0.250378
R4182 VSS.n1865 VSS.n1863 0.250378
R4183 VSS.n2402 VSS.n2400 0.250378
R4184 VSS.n2395 VSS.n2393 0.250378
R4185 VSS.n2393 VSS.n2391 0.250378
R4186 VSS.n2391 VSS.n2389 0.250378
R4187 VSS.n2383 VSS.n2381 0.250378
R4188 VSS.n2376 VSS.n2374 0.250378
R4189 VSS.n2374 VSS.n2372 0.250378
R4190 VSS.n2372 VSS.n2370 0.250378
R4191 VSS.n472 VSS.n471 0.244956
R4192 VSS.n2331 VSS.n2088 0.243357
R4193 VSS.n2331 VSS.n2330 0.243357
R4194 VSS.n2237 VSS.n2094 0.235179
R4195 VSS.n2241 VSS.n2240 0.230342
R4196 VSS.n1284 VSS.n1283 0.223034
R4197 VSS.n2927 VSS.n2926 0.21569
R4198 VSS.n925 VSS.n468 0.214179
R4199 VSS.n1861 VSS.n1860 0.206932
R4200 VSS.n2962 VSS.n5 0.206397
R4201 VSS.n2504 VSS 0.198759
R4202 VSS.n1392 VSS.n1391 0.197342
R4203 VSS.n1909 VSS.n1792 0.195902
R4204 VSS.n471 VSS.n468 0.195381
R4205 VSS.n265 VSS.n264 0.194786
R4206 VSS.n2680 VSS.n2521 0.189713
R4207 VSS.n2762 VSS.n2761 0.187772
R4208 VSS.n2687 VSS.n2686 0.187772
R4209 VSS.n2691 VSS.n2689 0.187772
R4210 VSS.n2675 VSS.n35 0.187772
R4211 VSS.n2935 VSS.n2934 0.187772
R4212 VSS.n1588 VSS.n1587 0.187772
R4213 VSS.n2891 VSS.n2890 0.187772
R4214 VSS.n2403 VSS.n2402 0.187772
R4215 VSS.n2400 VSS.n2398 0.187772
R4216 VSS.n2396 VSS.n2395 0.187772
R4217 VSS.n2381 VSS.n2379 0.187772
R4218 VSS.n2377 VSS.n2376 0.187772
R4219 VSS.n2370 VSS.n2368 0.187772
R4220 VSS.n1343 VSS.n1342 0.186654
R4221 VSS.n1352 VSS.n1351 0.186654
R4222 VSS.n2328 VSS.n2098 0.182889
R4223 VSS.n1357 VSS 0.180741
R4224 VSS.n1375 VSS.n1374 0.180741
R4225 VSS.n2315 VSS.n2098 0.171826
R4226 VSS.n2913 VSS.n487 0.170485
R4227 VSS.n2907 VSS.n504 0.161888
R4228 VSS.n1088 VSS.n1087 0.154772
R4229 VSS.n2092 VSS.n2091 0.154499
R4230 VSS.n732 VSS.n731 0.1479
R4231 VSS.n2387 VSS.n2383 0.147439
R4232 VSS.n1311 VSS.n1310 0.145743
R4233 VSS.n729 VSS.n589 0.1457
R4234 VSS.n2389 VSS.n2387 0.143772
R4235 VSS.n493 VSS.n492 0.143759
R4236 VSS.n2170 VSS.n2092 0.141558
R4237 VSS.n2094 VSS 0.140077
R4238 VSS.n2508 VSS.n647 0.139325
R4239 VSS.n2839 VSS.n647 0.136915
R4240 VSS.n1089 VSS.n1088 0.13605
R4241 VSS.n2244 VSS.n2243 0.134237
R4242 VSS VSS.n734 0.1292
R4243 VSS.n1589 VSS.n1588 0.125439
R4244 VSS.n2238 VSS.n2237 0.117447
R4245 VSS.n1862 VSS.n1856 0.11613
R4246 VSS.n1594 VSS.n474 0.115486
R4247 VSS.n1598 VSS.n474 0.115261
R4248 VSS.n1356 VSS.n1353 0.112678
R4249 VSS.n1356 VSS 0.112333
R4250 VSS.n2740 VSS.n646 0.109066
R4251 VSS.n2912 VSS.n2911 0.108254
R4252 VSS.n1353 VSS.n1352 0.094265
R4253 VSS.n2398 VSS.n2367 0.0866667
R4254 VSS.n2689 VSS.n2674 0.0848333
R4255 VSS.n2934 VSS.n33 0.0848333
R4256 VSS.n2377 VSS 0.0848333
R4257 VSS.n2906 VSS.n589 0.0794743
R4258 VSS.n1604 VSS.n1258 0.0724955
R4259 VSS VSS.n1591 0.0706301
R4260 VSS.n2783 VSS.n647 0.0701216
R4261 VSS.n2608 VSS.n2576 0.0693889
R4262 VSS.n1591 VSS.n1590 0.0684686
R4263 VSS.n2669 VSS.n2668 0.0682778
R4264 VSS.n2667 VSS.n2665 0.0671667
R4265 VSS.n2607 VSS.n2605 0.0671667
R4266 VSS.n2963 VSS.n2962 0.0669925
R4267 VSS.n2843 VSS.n2842 0.0662933
R4268 VSS.n2668 VSS.n2636 0.0660556
R4269 VSS.n2609 VSS.n2608 0.0649444
R4270 VSS.n2326 VSS.n2325 0.0637395
R4271 VSS.n2671 VSS.n2612 0.0621773
R4272 VSS.n2611 VSS.n2552 0.0621773
R4273 VSS.n2980 VSS.n2979 0.0573571
R4274 VSS.n2368 VSS 0.0555
R4275 VSS.n1344 VSS.n1336 0.0535995
R4276 VSS.n1345 VSS.n1336 0.0535995
R4277 VSS.n1349 VSS.n1338 0.0535995
R4278 VSS.n1350 VSS.n1334 0.0535995
R4279 VSS.n1350 VSS.n1349 0.0535995
R4280 VSS.n1345 VSS.n1337 0.0535995
R4281 VSS.n1344 VSS.n1335 0.0535995
R4282 VSS.n1246 VSS.n1244 0.0520218
R4283 VSS.n1248 VSS.n1246 0.0520218
R4284 VSS.n1250 VSS.n1248 0.0520218
R4285 VSS.n1252 VSS.n1250 0.0520218
R4286 VSS.n1254 VSS.n1252 0.0520218
R4287 VSS.n1256 VSS.n1254 0.0520218
R4288 VSS.n1348 VSS.n1347 0.049859
R4289 VSS.n1586 VSS 0.0479723
R4290 VSS.n2324 VSS.n2323 0.0472096
R4291 VSS.n2179 VSS.n2178 0.0472096
R4292 VSS.n1341 VSS.n1339 0.0467662
R4293 VSS.n2386 VSS.n2385 0.0435897
R4294 VSS.n2199 VSS.n2185 0.0416893
R4295 VSS.n2201 VSS.n2187 0.0416893
R4296 VSS.n2202 VSS.n2188 0.0416893
R4297 VSS.n2204 VSS.n2190 0.0416893
R4298 VSS.n2206 VSS.n2192 0.0416893
R4299 VSS.n2208 VSS.n2194 0.0416893
R4300 VSS.n2209 VSS.n2195 0.0416893
R4301 VSS.n2239 VSS.n2210 0.0416893
R4302 VSS.n2212 VSS.n2211 0.0416893
R4303 VSS.n2216 VSS.n2215 0.0416893
R4304 VSS.n2220 VSS.n2219 0.0416893
R4305 VSS.n2224 VSS.n2223 0.0416893
R4306 VSS.n2226 VSS.n2225 0.0416893
R4307 VSS.n2230 VSS.n2229 0.0416893
R4308 VSS.n2234 VSS.n2233 0.0416893
R4309 VSS.n2213 VSS.n2212 0.0416893
R4310 VSS.n2217 VSS.n2216 0.0416893
R4311 VSS.n2219 VSS.n2218 0.0416893
R4312 VSS.n2223 VSS.n2222 0.0416893
R4313 VSS.n2227 VSS.n2226 0.0416893
R4314 VSS.n2231 VSS.n2230 0.0416893
R4315 VSS.n2233 VSS.n2232 0.0416893
R4316 VSS.n2184 VSS.n2183 0.0416893
R4317 VSS.n2198 VSS.n2185 0.0416893
R4318 VSS.n2200 VSS.n2187 0.0416893
R4319 VSS.n2202 VSS.n2189 0.0416893
R4320 VSS.n2204 VSS.n2191 0.0416893
R4321 VSS.n2205 VSS.n2192 0.0416893
R4322 VSS.n2207 VSS.n2194 0.0416893
R4323 VSS.n2209 VSS.n2196 0.0416893
R4324 VSS.n2321 VSS.n2319 0.0414286
R4325 VSS.n2176 VSS.n2174 0.0414286
R4326 VSS.n2198 VSS.n2184 0.0414005
R4327 VSS.n2200 VSS.n2186 0.0414005
R4328 VSS.n2203 VSS.n2189 0.0414005
R4329 VSS.n2205 VSS.n2191 0.0414005
R4330 VSS.n2207 VSS.n2193 0.0414005
R4331 VSS.n2197 VSS.n2196 0.0414005
R4332 VSS.n2214 VSS.n2213 0.0414005
R4333 VSS.n2218 VSS.n2217 0.0414005
R4334 VSS.n2222 VSS.n2221 0.0414005
R4335 VSS.n2228 VSS.n2227 0.0414005
R4336 VSS.n2232 VSS.n2231 0.0414005
R4337 VSS.n2236 VSS.n2235 0.0414005
R4338 VSS.n2211 VSS.n2210 0.0414005
R4339 VSS.n2215 VSS.n2214 0.0414005
R4340 VSS.n2221 VSS.n2220 0.0414005
R4341 VSS.n2225 VSS.n2224 0.0414005
R4342 VSS.n2229 VSS.n2228 0.0414005
R4343 VSS.n2235 VSS.n2234 0.0414005
R4344 VSS.n2199 VSS.n2186 0.0414005
R4345 VSS.n2201 VSS.n2188 0.0414005
R4346 VSS.n2203 VSS.n2190 0.0414005
R4347 VSS.n2206 VSS.n2193 0.0414005
R4348 VSS.n2208 VSS.n2195 0.0414005
R4349 VSS.n2242 VSS.n2197 0.0414005
R4350 VSS.n2316 VSS.n2315 0.0413456
R4351 VSS.n2171 VSS.n2170 0.0413456
R4352 VSS.n2749 VSS.n647 0.0410355
R4353 VSS.n2521 VSS.n37 0.040929
R4354 VSS.n2687 VSS.n2674 0.0408333
R4355 VSS.n35 VSS.n33 0.0408333
R4356 VSS.n2379 VSS 0.0408333
R4357 VSS.n2319 VSS.n2318 0.040822
R4358 VSS.n2174 VSS.n2173 0.040822
R4359 VSS VSS.n1356 0.040259
R4360 VSS.n2625 VSS.n2614 0.0400673
R4361 VSS.n2627 VSS.n2616 0.0400673
R4362 VSS.n2629 VSS.n2618 0.0400673
R4363 VSS.n2630 VSS.n2619 0.0400673
R4364 VSS.n2632 VSS.n2621 0.0400673
R4365 VSS.n2634 VSS.n2623 0.0400673
R4366 VSS.n2651 VSS.n2638 0.0400673
R4367 VSS.n2652 VSS.n2639 0.0400673
R4368 VSS.n2654 VSS.n2641 0.0400673
R4369 VSS.n2656 VSS.n2643 0.0400673
R4370 VSS.n2658 VSS.n2645 0.0400673
R4371 VSS.n2659 VSS.n2646 0.0400673
R4372 VSS.n2661 VSS.n2648 0.0400673
R4373 VSS.n2663 VSS.n2650 0.0400673
R4374 VSS.n2652 VSS.n2640 0.0400673
R4375 VSS.n2654 VSS.n2642 0.0400673
R4376 VSS.n2655 VSS.n2643 0.0400673
R4377 VSS.n2657 VSS.n2645 0.0400673
R4378 VSS.n2659 VSS.n2647 0.0400673
R4379 VSS.n2661 VSS.n2649 0.0400673
R4380 VSS.n2662 VSS.n2650 0.0400673
R4381 VSS.n2625 VSS.n2615 0.0400673
R4382 VSS.n2626 VSS.n2616 0.0400673
R4383 VSS.n2628 VSS.n2618 0.0400673
R4384 VSS.n2630 VSS.n2620 0.0400673
R4385 VSS.n2632 VSS.n2622 0.0400673
R4386 VSS.n2633 VSS.n2623 0.0400673
R4387 VSS.n2565 VSS.n2554 0.0400673
R4388 VSS.n2567 VSS.n2556 0.0400673
R4389 VSS.n2569 VSS.n2558 0.0400673
R4390 VSS.n2570 VSS.n2559 0.0400673
R4391 VSS.n2572 VSS.n2561 0.0400673
R4392 VSS.n2574 VSS.n2563 0.0400673
R4393 VSS.n2592 VSS.n2580 0.0400673
R4394 VSS.n2594 VSS.n2582 0.0400673
R4395 VSS.n2595 VSS.n2583 0.0400673
R4396 VSS.n2597 VSS.n2585 0.0400673
R4397 VSS.n2599 VSS.n2587 0.0400673
R4398 VSS.n2601 VSS.n2589 0.0400673
R4399 VSS.n2602 VSS.n2590 0.0400673
R4400 VSS.n2591 VSS.n2578 0.0400673
R4401 VSS.n2592 VSS.n2579 0.0400673
R4402 VSS.n2594 VSS.n2581 0.0400673
R4403 VSS.n2596 VSS.n2583 0.0400673
R4404 VSS.n2598 VSS.n2585 0.0400673
R4405 VSS.n2599 VSS.n2586 0.0400673
R4406 VSS.n2601 VSS.n2588 0.0400673
R4407 VSS.n2603 VSS.n2590 0.0400673
R4408 VSS.n2565 VSS.n2555 0.0400673
R4409 VSS.n2566 VSS.n2556 0.0400673
R4410 VSS.n2568 VSS.n2558 0.0400673
R4411 VSS.n2570 VSS.n2560 0.0400673
R4412 VSS.n2572 VSS.n2562 0.0400673
R4413 VSS.n2573 VSS.n2563 0.0400673
R4414 VSS.n733 VSS.n727 0.0399565
R4415 VSS.n730 VSS.n728 0.0399565
R4416 VSS.n2626 VSS.n2615 0.0397902
R4417 VSS.n2628 VSS.n2617 0.0397902
R4418 VSS.n2631 VSS.n2620 0.0397902
R4419 VSS.n2633 VSS.n2622 0.0397902
R4420 VSS.n2635 VSS.n2624 0.0397902
R4421 VSS.n2653 VSS.n2640 0.0397902
R4422 VSS.n2655 VSS.n2642 0.0397902
R4423 VSS.n2657 VSS.n2644 0.0397902
R4424 VSS.n2660 VSS.n2647 0.0397902
R4425 VSS.n2662 VSS.n2649 0.0397902
R4426 VSS.n2664 VSS.n2637 0.0397902
R4427 VSS.n2651 VSS.n2639 0.0397902
R4428 VSS.n2653 VSS.n2641 0.0397902
R4429 VSS.n2656 VSS.n2644 0.0397902
R4430 VSS.n2658 VSS.n2646 0.0397902
R4431 VSS.n2660 VSS.n2648 0.0397902
R4432 VSS.n2664 VSS.n2663 0.0397902
R4433 VSS.n2614 VSS.n2613 0.0397902
R4434 VSS.n2627 VSS.n2617 0.0397902
R4435 VSS.n2629 VSS.n2619 0.0397902
R4436 VSS.n2631 VSS.n2621 0.0397902
R4437 VSS.n2634 VSS.n2624 0.0397902
R4438 VSS.n2566 VSS.n2555 0.0397902
R4439 VSS.n2568 VSS.n2557 0.0397902
R4440 VSS.n2571 VSS.n2560 0.0397902
R4441 VSS.n2573 VSS.n2562 0.0397902
R4442 VSS.n2575 VSS.n2564 0.0397902
R4443 VSS.n2591 VSS.n2579 0.0397902
R4444 VSS.n2593 VSS.n2581 0.0397902
R4445 VSS.n2596 VSS.n2584 0.0397902
R4446 VSS.n2598 VSS.n2586 0.0397902
R4447 VSS.n2600 VSS.n2588 0.0397902
R4448 VSS.n2604 VSS.n2603 0.0397902
R4449 VSS.n2554 VSS.n2553 0.0397902
R4450 VSS.n2593 VSS.n2580 0.0397902
R4451 VSS.n2595 VSS.n2582 0.0397902
R4452 VSS.n2597 VSS.n2584 0.0397902
R4453 VSS.n2600 VSS.n2587 0.0397902
R4454 VSS.n2602 VSS.n2589 0.0397902
R4455 VSS.n2604 VSS.n2577 0.0397902
R4456 VSS.n2567 VSS.n2557 0.0397902
R4457 VSS.n2569 VSS.n2559 0.0397902
R4458 VSS.n2571 VSS.n2561 0.0397902
R4459 VSS.n2574 VSS.n2564 0.0397902
R4460 VSS.n2396 VSS.n2367 0.039
R4461 VSS.n1244 VSS.n1242 0.038896
R4462 VSS.n1257 VSS.n1256 0.038896
R4463 VSS.n2761 VSS.n2422 0.0371667
R4464 VSS.n2781 VSS.n2780 0.0369331
R4465 VSS.n2782 VSS.n2781 0.0359941
R4466 VSS.n1587 VSS.n1284 0.0357621
R4467 VSS.n2043 VSS.n2014 0.0339434
R4468 VSS.n835 VSS.n833 0.0338333
R4469 VSS.n832 VSS.n830 0.0338333
R4470 VSS.n829 VSS.n827 0.0338333
R4471 VSS.n826 VSS.n824 0.0338333
R4472 VSS.n823 VSS.n821 0.0338333
R4473 VSS.n820 VSS.n818 0.0338333
R4474 VSS.n817 VSS.n815 0.0338333
R4475 VSS.n814 VSS.n812 0.0338333
R4476 VSS.n811 VSS.n809 0.0338333
R4477 VSS.n808 VSS.n806 0.0338333
R4478 VSS.n805 VSS.n803 0.0338333
R4479 VSS.n802 VSS.n800 0.0338333
R4480 VSS.n799 VSS.n797 0.0338333
R4481 VSS.n796 VSS.n794 0.0338333
R4482 VSS.n793 VSS.n791 0.0338333
R4483 VSS.n790 VSS.n788 0.0338333
R4484 VSS.n787 VSS.n785 0.0338333
R4485 VSS.n784 VSS.n782 0.0327645
R4486 VSS.n1645 VSS.n949 0.0305
R4487 VSS.n1644 VSS.n1643 0.0305
R4488 VSS.n1641 VSS.n951 0.0305
R4489 VSS.n1640 VSS.n1639 0.0305
R4490 VSS.n1637 VSS.n953 0.0305
R4491 VSS.n1636 VSS.n1635 0.0305
R4492 VSS.n1633 VSS.n955 0.0305
R4493 VSS.n1632 VSS.n1631 0.0305
R4494 VSS.n1629 VSS.n957 0.0305
R4495 VSS.n1628 VSS.n1627 0.0305
R4496 VSS.n1625 VSS.n959 0.0305
R4497 VSS.n1624 VSS.n1623 0.0305
R4498 VSS.n1621 VSS.n961 0.0305
R4499 VSS.n1620 VSS.n1619 0.0305
R4500 VSS.n1617 VSS.n963 0.0305
R4501 VSS.n1616 VSS.n1615 0.0305
R4502 VSS.n1613 VSS.n965 0.0305
R4503 VSS.n1612 VSS.n1611 0.0305
R4504 VSS.n1645 VSS.n1644 0.0271667
R4505 VSS.n1643 VSS.n951 0.0271667
R4506 VSS.n1641 VSS.n1640 0.0271667
R4507 VSS.n1639 VSS.n953 0.0271667
R4508 VSS.n1637 VSS.n1636 0.0271667
R4509 VSS.n1635 VSS.n955 0.0271667
R4510 VSS.n1633 VSS.n1632 0.0271667
R4511 VSS.n1631 VSS.n957 0.0271667
R4512 VSS.n1629 VSS.n1628 0.0271667
R4513 VSS.n1627 VSS.n959 0.0271667
R4514 VSS.n1625 VSS.n1624 0.0271667
R4515 VSS.n1623 VSS.n961 0.0271667
R4516 VSS.n1621 VSS.n1620 0.0271667
R4517 VSS.n1619 VSS.n963 0.0271667
R4518 VSS.n1617 VSS.n1616 0.0271667
R4519 VSS.n1615 VSS.n965 0.0271667
R4520 VSS.n1613 VSS.n1612 0.0271667
R4521 VSS.n1611 VSS.n1609 0.0271667
R4522 VSS.n1343 VSS.n1335 0.0270498
R4523 VSS.n1348 VSS.n1338 0.0270498
R4524 VSS.n1351 VSS.n1334 0.0270498
R4525 VSS.n1346 VSS.n1337 0.0270498
R4526 VSS.n1220 VSS.n990 0.0265778
R4527 VSS.n1647 VSS.n949 0.0260978
R4528 VSS.n2671 VSS.n2670 0.0255
R4529 VSS.n2611 VSS.n2610 0.0255
R4530 VSS.n833 VSS.n832 0.0238333
R4531 VSS.n830 VSS.n829 0.0238333
R4532 VSS.n827 VSS.n826 0.0238333
R4533 VSS.n824 VSS.n823 0.0238333
R4534 VSS.n821 VSS.n820 0.0238333
R4535 VSS.n818 VSS.n817 0.0238333
R4536 VSS.n815 VSS.n814 0.0238333
R4537 VSS.n812 VSS.n811 0.0238333
R4538 VSS.n809 VSS.n808 0.0238333
R4539 VSS.n806 VSS.n805 0.0238333
R4540 VSS.n803 VSS.n802 0.0238333
R4541 VSS.n800 VSS.n799 0.0238333
R4542 VSS.n797 VSS.n796 0.0238333
R4543 VSS.n794 VSS.n793 0.0238333
R4544 VSS.n791 VSS.n790 0.0238333
R4545 VSS.n788 VSS.n787 0.0238333
R4546 VSS.n785 VSS.n784 0.0238333
R4547 VSS.n1228 VSS.n1166 0.0223103
R4548 VSS.n1973 VSS.n1972 0.0217327
R4549 VSS.n1352 VSS 0.0216538
R4550 VSS.n2243 VSS.n2183 0.021239
R4551 VSS.n2240 VSS.n2239 0.021239
R4552 VSS.n2238 VSS.n2236 0.0209502
R4553 VSS.n2242 VSS.n2241 0.0209502
R4554 VSS.n2638 VSS.n2636 0.0204222
R4555 VSS.n2578 VSS.n2576 0.0204222
R4556 VSS.n730 VSS.n729 0.0202282
R4557 VSS.n731 VSS.n728 0.0202282
R4558 VSS.n733 VSS.n732 0.0202282
R4559 VSS.n734 VSS.n727 0.0202282
R4560 VSS.n2670 VSS.n2613 0.0201451
R4561 VSS.n2665 VSS.n2637 0.0201451
R4562 VSS.n2669 VSS.n2635 0.0201451
R4563 VSS.n2610 VSS.n2553 0.0201451
R4564 VSS.n2605 VSS.n2577 0.0201451
R4565 VSS.n2609 VSS.n2575 0.0201451
R4566 VSS.n928 VSS.n927 0.0198978
R4567 VSS.n735 VSS 0.0190326
R4568 VSS.n1341 VSS.n1340 0.0188542
R4569 VSS.n1234 VSS.n1233 0.0185094
R4570 VSS.n2237 VSS.n2095 0.0182941
R4571 VSS.n2090 VSS.n1973 0.0180291
R4572 VSS.n2073 VSS.n1751 0.0176625
R4573 VSS.n2078 VSS.n2077 0.0176625
R4574 VSS.n2790 VSS.n2789 0.0175387
R4575 VSS.n2788 VSS.n2787 0.0172882
R4576 VSS.n2830 VSS.n2829 0.0172882
R4577 VSS.n2833 VSS.n2832 0.0172882
R4578 VSS.n2786 VSS.n2785 0.0170376
R4579 VSS.n2793 VSS.n2792 0.0170376
R4580 VSS.n2828 VSS.n2827 0.0170376
R4581 VSS.n2835 VSS.n2834 0.0170376
R4582 VSS.n2795 VSS.n2794 0.016787
R4583 VSS.n2826 VSS.n2825 0.016787
R4584 VSS.n2836 VSS.n2404 0.016787
R4585 VSS.n2875 VSS.n474 0.0166792
R4586 VSS.n2797 VSS.n2796 0.0165364
R4587 VSS.n2799 VSS.n2798 0.0162859
R4588 VSS.n2824 VSS.n2823 0.0162859
R4589 VSS.n2822 VSS.n2821 0.0160353
R4590 VSS.n2801 VSS.n2800 0.0157847
R4591 VSS.n2820 VSS.n2819 0.0157847
R4592 VSS.n2265 VSS.n2264 0.0155475
R4593 VSS.n2269 VSS.n2268 0.0155475
R4594 VSS.n2271 VSS.n2270 0.0155475
R4595 VSS.n2275 VSS.n2274 0.0155475
R4596 VSS.n2279 VSS.n2278 0.0155475
R4597 VSS.n2283 VSS.n2282 0.0155475
R4598 VSS.n2285 VSS.n2284 0.0155475
R4599 VSS.n2304 VSS.n2290 0.0155475
R4600 VSS.n2306 VSS.n2292 0.0155475
R4601 VSS.n2307 VSS.n2293 0.0155475
R4602 VSS.n2309 VSS.n2295 0.0155475
R4603 VSS.n2311 VSS.n2297 0.0155475
R4604 VSS.n2313 VSS.n2299 0.0155475
R4605 VSS.n2314 VSS.n2300 0.0155475
R4606 VSS.n2322 VSS.n2262 0.0155475
R4607 VSS.n2264 VSS.n2263 0.0155475
R4608 VSS.n2268 VSS.n2267 0.0155475
R4609 VSS.n2272 VSS.n2271 0.0155475
R4610 VSS.n2276 VSS.n2275 0.0155475
R4611 VSS.n2278 VSS.n2277 0.0155475
R4612 VSS.n2282 VSS.n2281 0.0155475
R4613 VSS.n2286 VSS.n2285 0.0155475
R4614 VSS.n2314 VSS.n2301 0.0155475
R4615 VSS.n2312 VSS.n2299 0.0155475
R4616 VSS.n2310 VSS.n2297 0.0155475
R4617 VSS.n2309 VSS.n2296 0.0155475
R4618 VSS.n2307 VSS.n2294 0.0155475
R4619 VSS.n2305 VSS.n2292 0.0155475
R4620 VSS.n2303 VSS.n2290 0.0155475
R4621 VSS.n2289 VSS.n2288 0.0155475
R4622 VSS.n2120 VSS.n2119 0.0155475
R4623 VSS.n2124 VSS.n2123 0.0155475
R4624 VSS.n2126 VSS.n2125 0.0155475
R4625 VSS.n2130 VSS.n2129 0.0155475
R4626 VSS.n2134 VSS.n2133 0.0155475
R4627 VSS.n2138 VSS.n2137 0.0155475
R4628 VSS.n2140 VSS.n2139 0.0155475
R4629 VSS.n2159 VSS.n2145 0.0155475
R4630 VSS.n2161 VSS.n2147 0.0155475
R4631 VSS.n2162 VSS.n2148 0.0155475
R4632 VSS.n2164 VSS.n2150 0.0155475
R4633 VSS.n2166 VSS.n2152 0.0155475
R4634 VSS.n2168 VSS.n2154 0.0155475
R4635 VSS.n2169 VSS.n2155 0.0155475
R4636 VSS.n2169 VSS.n2156 0.0155475
R4637 VSS.n2167 VSS.n2154 0.0155475
R4638 VSS.n2165 VSS.n2152 0.0155475
R4639 VSS.n2164 VSS.n2151 0.0155475
R4640 VSS.n2162 VSS.n2149 0.0155475
R4641 VSS.n2160 VSS.n2147 0.0155475
R4642 VSS.n2158 VSS.n2145 0.0155475
R4643 VSS.n2144 VSS.n2143 0.0155475
R4644 VSS.n2141 VSS.n2140 0.0155475
R4645 VSS.n2137 VSS.n2136 0.0155475
R4646 VSS.n2133 VSS.n2132 0.0155475
R4647 VSS.n2131 VSS.n2130 0.0155475
R4648 VSS.n2127 VSS.n2126 0.0155475
R4649 VSS.n2123 VSS.n2122 0.0155475
R4650 VSS.n2119 VSS.n2118 0.0155475
R4651 VSS.n2177 VSS.n2117 0.0155475
R4652 VSS.n2803 VSS.n2802 0.0155342
R4653 VSS.n2818 VSS.n2817 0.0155342
R4654 VSS.n2263 VSS.n2262 0.0154465
R4655 VSS.n2267 VSS.n2266 0.0154465
R4656 VSS.n2273 VSS.n2272 0.0154465
R4657 VSS.n2277 VSS.n2276 0.0154465
R4658 VSS.n2281 VSS.n2280 0.0154465
R4659 VSS.n2287 VSS.n2286 0.0154465
R4660 VSS.n2303 VSS.n2289 0.0154465
R4661 VSS.n2305 VSS.n2291 0.0154465
R4662 VSS.n2308 VSS.n2294 0.0154465
R4663 VSS.n2310 VSS.n2296 0.0154465
R4664 VSS.n2312 VSS.n2298 0.0154465
R4665 VSS.n2302 VSS.n2301 0.0154465
R4666 VSS.n2266 VSS.n2265 0.0154465
R4667 VSS.n2270 VSS.n2269 0.0154465
R4668 VSS.n2274 VSS.n2273 0.0154465
R4669 VSS.n2280 VSS.n2279 0.0154465
R4670 VSS.n2284 VSS.n2283 0.0154465
R4671 VSS.n2320 VSS.n2287 0.0154465
R4672 VSS.n2317 VSS.n2302 0.0154465
R4673 VSS.n2313 VSS.n2300 0.0154465
R4674 VSS.n2311 VSS.n2298 0.0154465
R4675 VSS.n2308 VSS.n2295 0.0154465
R4676 VSS.n2306 VSS.n2293 0.0154465
R4677 VSS.n2304 VSS.n2291 0.0154465
R4678 VSS.n2118 VSS.n2117 0.0154465
R4679 VSS.n2122 VSS.n2121 0.0154465
R4680 VSS.n2128 VSS.n2127 0.0154465
R4681 VSS.n2132 VSS.n2131 0.0154465
R4682 VSS.n2136 VSS.n2135 0.0154465
R4683 VSS.n2142 VSS.n2141 0.0154465
R4684 VSS.n2158 VSS.n2144 0.0154465
R4685 VSS.n2160 VSS.n2146 0.0154465
R4686 VSS.n2163 VSS.n2149 0.0154465
R4687 VSS.n2165 VSS.n2151 0.0154465
R4688 VSS.n2167 VSS.n2153 0.0154465
R4689 VSS.n2157 VSS.n2156 0.0154465
R4690 VSS.n2172 VSS.n2157 0.0154465
R4691 VSS.n2168 VSS.n2155 0.0154465
R4692 VSS.n2166 VSS.n2153 0.0154465
R4693 VSS.n2163 VSS.n2150 0.0154465
R4694 VSS.n2161 VSS.n2148 0.0154465
R4695 VSS.n2159 VSS.n2146 0.0154465
R4696 VSS.n2175 VSS.n2142 0.0154465
R4697 VSS.n2139 VSS.n2138 0.0154465
R4698 VSS.n2135 VSS.n2134 0.0154465
R4699 VSS.n2129 VSS.n2128 0.0154465
R4700 VSS.n2125 VSS.n2124 0.0154465
R4701 VSS.n2121 VSS.n2120 0.0154465
R4702 VSS.n2805 VSS.n2804 0.0152836
R4703 VSS.n2816 VSS.n2815 0.015033
R4704 VSS.n2807 VSS.n2806 0.0147825
R4705 VSS.n2814 VSS.n2813 0.0147825
R4706 VSS.n2809 VSS.n2808 0.0145319
R4707 VSS.n2756 VSS.n2755 0.0144552
R4708 VSS.n1860 VSS.n1693 0.0143643
R4709 VSS.n2811 VSS.n2810 0.0142813
R4710 VSS.n2759 VSS.n2758 0.01425
R4711 VSS.n2502 VSS.n2501 0.01425
R4712 VSS.n2516 VSS.n2515 0.01425
R4713 VSS.n2753 VSS.n2437 0.0140448
R4714 VSS.n2499 VSS.n2474 0.0140448
R4715 VSS.n2514 VSS.n2513 0.0140448
R4716 VSS.n2879 VSS.n648 0.0138661
R4717 VSS.n2440 VSS.n2436 0.0138396
R4718 VSS.n2498 VSS.n2497 0.0138396
R4719 VSS.n2512 VSS.n2511 0.0138396
R4720 VSS.n2441 VSS.n2435 0.0136343
R4721 VSS.n2964 VSS.n2963 0.0136343
R4722 VSS.n2965 VSS.n2964 0.0136343
R4723 VSS.n2966 VSS.n2965 0.0136343
R4724 VSS.n2967 VSS.n2966 0.0136343
R4725 VSS.n2096 VSS.n2095 0.0134412
R4726 VSS.n2460 VSS.n2434 0.0134291
R4727 VSS.n2495 VSS.n2475 0.0134291
R4728 VSS.n2812 VSS.n2811 0.0132734
R4729 VSS.n2494 VSS.n2493 0.0132239
R4730 VSS.n1298 VSS.n187 0.0131997
R4731 VSS.n1463 VSS.n1462 0.0131997
R4732 VSS.n2461 VSS.n2433 0.0130187
R4733 VSS.n2491 VSS.n2476 0.0130187
R4734 VSS.n926 VSS.n925 0.0129329
R4735 VSS.n231 VSS.n230 0.0128841
R4736 VSS.n1457 VSS.n1454 0.0128841
R4737 VSS.n2464 VSS.n2432 0.0128134
R4738 VSS.n2490 VSS.n2489 0.0128134
R4739 VSS.n2813 VSS.n2812 0.0127722
R4740 VSS.n229 VSS.n205 0.012702
R4741 VSS.n219 VSS.n190 0.012702
R4742 VSS.n211 VSS.n189 0.012702
R4743 VSS.n1452 VSS.n1450 0.012702
R4744 VSS.n1412 VSS.n1409 0.012702
R4745 VSS.n1410 VSS.n1408 0.012702
R4746 VSS.n2465 VSS.n2431 0.0126082
R4747 VSS.n228 VSS.n204 0.0125199
R4748 VSS.n227 VSS.n203 0.0125199
R4749 VSS.n215 VSS.n192 0.0125199
R4750 VSS.n212 VSS.n191 0.0125199
R4751 VSS.n1449 VSS.n1448 0.0125199
R4752 VSS.n1446 VSS.n1445 0.0125199
R4753 VSS.n1417 VSS.n1414 0.0125199
R4754 VSS.n1415 VSS.n1413 0.0125199
R4755 VSS.n1456 VSS.n1405 0.0124713
R4756 VSS.n780 VSS.n778 0.0124565
R4757 VSS.n777 VSS.n775 0.0124565
R4758 VSS.n774 VSS.n772 0.0124565
R4759 VSS.n771 VSS.n769 0.0124565
R4760 VSS.n768 VSS.n766 0.0124565
R4761 VSS.n765 VSS.n763 0.0124565
R4762 VSS.n762 VSS.n760 0.0124565
R4763 VSS.n759 VSS.n757 0.0124565
R4764 VSS.n756 VSS.n754 0.0124565
R4765 VSS.n753 VSS.n751 0.0124565
R4766 VSS.n750 VSS.n748 0.0124565
R4767 VSS.n747 VSS.n745 0.0124565
R4768 VSS.n744 VSS.n742 0.0124565
R4769 VSS.n741 VSS.n739 0.0124565
R4770 VSS.n738 VSS.n736 0.0124565
R4771 VSS.n2487 VSS.n2477 0.012403
R4772 VSS.n226 VSS.n202 0.0123377
R4773 VSS.n225 VSS.n201 0.0123377
R4774 VSS.n213 VSS.n193 0.0123377
R4775 VSS.n1561 VSS.n184 0.0123377
R4776 VSS.n1444 VSS.n1443 0.0123377
R4777 VSS.n1441 VSS.n1440 0.0123377
R4778 VSS.n1420 VSS.n1418 0.0123377
R4779 VSS.n1571 VSS.n1287 0.0123377
R4780 VSS.n1240 VSS.n989 0.0122572
R4781 VSS.n2479 VSS.n2430 0.0121978
R4782 VSS.n2486 VSS.n2485 0.0121978
R4783 VSS.n2483 VSS.n2478 0.0121745
R4784 VSS.n224 VSS.n200 0.0121556
R4785 VSS.n223 VSS.n199 0.0121556
R4786 VSS.n208 VSS.n195 0.0121556
R4787 VSS.n214 VSS.n194 0.0121556
R4788 VSS.n1562 VSS.n185 0.0121556
R4789 VSS.n1439 VSS.n1438 0.0121556
R4790 VSS.n1436 VSS.n1435 0.0121556
R4791 VSS.n1425 VSS.n1423 0.0121556
R4792 VSS.n1422 VSS.n1419 0.0121556
R4793 VSS.n1466 VSS.n1286 0.0121556
R4794 VSS.n2481 VSS.n2429 0.0119925
R4795 VSS.n222 VSS.n198 0.0119735
R4796 VSS.n207 VSS.n196 0.0119735
R4797 VSS.n1434 VSS.n1433 0.0119735
R4798 VSS.n1427 VSS.n1424 0.0119735
R4799 VSS.n1240 VSS.n990 0.0118635
R4800 VSS.n221 VSS.n197 0.0117914
R4801 VSS.n1431 VSS.n1430 0.0117914
R4802 VSS.n2483 VSS.n2482 0.0117873
R4803 VSS.n1235 VSS.n1234 0.01178
R4804 VSS.n2485 VSS.n2478 0.0115135
R4805 VSS.n2890 VSS.n605 0.0115
R4806 VSS.n2872 VSS.n1678 0.011493
R4807 VSS.n724 VSS.n723 0.0112609
R4808 VSS.n1674 VSS.n936 0.0112609
R4809 VSS.n1673 VSS.n1672 0.0112609
R4810 VSS.n1670 VSS.n937 0.0112609
R4811 VSS.n1669 VSS.n1668 0.0112609
R4812 VSS.n1666 VSS.n939 0.0112609
R4813 VSS.n1665 VSS.n1664 0.0112609
R4814 VSS.n1662 VSS.n941 0.0112609
R4815 VSS.n1661 VSS.n1660 0.0112609
R4816 VSS.n1658 VSS.n943 0.0112609
R4817 VSS.n1657 VSS.n1656 0.0112609
R4818 VSS.n1654 VSS.n945 0.0112609
R4819 VSS.n1653 VSS.n1652 0.0112609
R4820 VSS.n1650 VSS.n947 0.0112609
R4821 VSS.n4 VSS.n3 0.0111131
R4822 VSS.n2975 VSS.n4 0.0111131
R4823 VSS.n2975 VSS.n2974 0.0111131
R4824 VSS.n2974 VSS.n2971 0.0111131
R4825 VSS.n2971 VSS.n2970 0.0111131
R4826 VSS.n2977 VSS.n2976 0.0111131
R4827 VSS.n2973 VSS.n2972 0.0111131
R4828 VSS.n2969 VSS.n0 0.0111131
R4829 VSS.n908 VSS.n907 0.0109035
R4830 VSS.n928 VSS.n924 0.0109035
R4831 VSS.n2331 VSS.n2089 0.010716
R4832 VSS.n1749 VSS.n1693 0.0106772
R4833 VSS.n2870 VSS.n2869 0.0106772
R4834 VSS.n1573 VSS.n1572 0.0106728
R4835 VSS.n1957 VSS.n1753 0.010486
R4836 VSS.n1750 VSS.n1721 0.010486
R4837 VSS.n2071 VSS.n2042 0.010486
R4838 VSS.n2336 VSS.n2079 0.010486
R4839 VSS.n1958 VSS.n1754 0.0103324
R4840 VSS.n2070 VSS.n2041 0.0103324
R4841 VSS.n77 VSS.n72 0.0102509
R4842 VSS.n1956 VSS.n1755 0.0101788
R4843 VSS.n1722 VSS.n1720 0.0101788
R4844 VSS.n2069 VSS.n2040 0.0101788
R4845 VSS.n2337 VSS.n2080 0.0101788
R4846 VSS.n1590 VSS.n1589 0.0101622
R4847 VSS.n725 VSS.n724 0.0100652
R4848 VSS.n936 VSS.n723 0.0100652
R4849 VSS.n1674 VSS.n1673 0.0100652
R4850 VSS.n1672 VSS.n937 0.0100652
R4851 VSS.n1670 VSS.n1669 0.0100652
R4852 VSS.n1668 VSS.n939 0.0100652
R4853 VSS.n1666 VSS.n1665 0.0100652
R4854 VSS.n1664 VSS.n941 0.0100652
R4855 VSS.n1662 VSS.n1661 0.0100652
R4856 VSS.n1660 VSS.n943 0.0100652
R4857 VSS.n1658 VSS.n1657 0.0100652
R4858 VSS.n1656 VSS.n945 0.0100652
R4859 VSS.n1654 VSS.n1653 0.0100652
R4860 VSS.n1652 VSS.n947 0.0100652
R4861 VSS.n1650 VSS.n1649 0.0100652
R4862 VSS.n1959 VSS.n1756 0.0100251
R4863 VSS.n1723 VSS.n1719 0.0100251
R4864 VSS.n2068 VSS.n2039 0.0100251
R4865 VSS.n2338 VSS.n2081 0.0100251
R4866 VSS.n2792 VSS.n2791 0.0100162
R4867 VSS.n1724 VSS.n1718 0.00987151
R4868 VSS.n2339 VSS.n2082 0.00987151
R4869 VSS.n2831 VSS.n2830 0.00976566
R4870 VSS.n2832 VSS.n2831 0.00976566
R4871 VSS.n1955 VSS.n1757 0.00971788
R4872 VSS.n2067 VSS.n2038 0.00971788
R4873 VSS.n1960 VSS.n1758 0.00956425
R4874 VSS.n1725 VSS.n1717 0.00956425
R4875 VSS.n2066 VSS.n2037 0.00956425
R4876 VSS.n2340 VSS.n2083 0.00956425
R4877 VSS.n2074 VSS.n2073 0.00955418
R4878 VSS.n2077 VSS.n2076 0.00955418
R4879 VSS.n2331 VSS.n2329 0.00952412
R4880 VSS.n2791 VSS.n2790 0.00951509
R4881 VSS VSS.n725 0.00946739
R4882 VSS.n1954 VSS.n1759 0.00941061
R4883 VSS.n1726 VSS.n1716 0.00941061
R4884 VSS.n2065 VSS.n2036 0.00941061
R4885 VSS.n2868 VSS.n2084 0.00941061
R4886 VSS.n220 VSS.n197 0.00928469
R4887 VSS.n220 VSS.n196 0.00926975
R4888 VSS.n1727 VSS.n1715 0.00925698
R4889 VSS.n2341 VSS.n2009 0.00925698
R4890 VSS.n1961 VSS.n1760 0.00910335
R4891 VSS.n1728 VSS.n1714 0.00910335
R4892 VSS.n2064 VSS.n2035 0.00910335
R4893 VSS.n2867 VSS.n2010 0.00910335
R4894 VSS.n927 VSS.n926 0.00909626
R4895 VSS.n1953 VSS.n1761 0.00894972
R4896 VSS.n2063 VSS.n2034 0.00894972
R4897 VSS.n778 VSS.n777 0.00886957
R4898 VSS.n775 VSS.n774 0.00886957
R4899 VSS.n772 VSS.n771 0.00886957
R4900 VSS.n769 VSS.n768 0.00886957
R4901 VSS.n766 VSS.n765 0.00886957
R4902 VSS.n763 VSS.n762 0.00886957
R4903 VSS.n760 VSS.n759 0.00886957
R4904 VSS.n757 VSS.n756 0.00886957
R4905 VSS.n754 VSS.n753 0.00886957
R4906 VSS.n751 VSS.n750 0.00886957
R4907 VSS.n748 VSS.n747 0.00886957
R4908 VSS.n745 VSS.n744 0.00886957
R4909 VSS.n742 VSS.n741 0.00886957
R4910 VSS.n739 VSS.n738 0.00886957
R4911 VSS.n736 VSS.n735 0.00886957
R4912 VSS.n1962 VSS.n1762 0.00879609
R4913 VSS.n1729 VSS.n1713 0.00879609
R4914 VSS.n2062 VSS.n2033 0.00879609
R4915 VSS.n2864 VSS.n2342 0.00879609
R4916 VSS.n1952 VSS.n1763 0.00864246
R4917 VSS.n1730 VSS.n1712 0.00864246
R4918 VSS.n2061 VSS.n2032 0.00864246
R4919 VSS.n2866 VSS.n2865 0.00864246
R4920 VSS.n1164 VSS.n1163 0.00856034
R4921 VSS.n1731 VSS.n1711 0.00848883
R4922 VSS.n2860 VSS.n2343 0.00848883
R4923 VSS.n1963 VSS.n1764 0.0083352
R4924 VSS.n2060 VSS.n2031 0.0083352
R4925 VSS.n1951 VSS.n1765 0.00818156
R4926 VSS.n1732 VSS.n1710 0.00818156
R4927 VSS.n2059 VSS.n2030 0.00818156
R4928 VSS.n2863 VSS.n2862 0.00818156
R4929 VSS.n2758 VSS.n2427 0.00817997
R4930 VSS.n2517 VSS.n2502 0.00817997
R4931 VSS.n2517 VSS.n2516 0.00817997
R4932 VSS.n2323 VSS.n2322 0.00807426
R4933 VSS.n2318 VSS.n2288 0.00807426
R4934 VSS.n2178 VSS.n2177 0.00807426
R4935 VSS.n2173 VSS.n2143 0.00807426
R4936 VSS.n366 VSS.n365 0.00806999
R4937 VSS.n254 VSS.n235 0.00806999
R4938 VSS.n1964 VSS.n1766 0.00802793
R4939 VSS.n1733 VSS.n1709 0.00802793
R4940 VSS.n2058 VSS.n2029 0.00802793
R4941 VSS.n2856 VSS.n2344 0.00802793
R4942 VSS.n2838 VSS.n2837 0.00801708
R4943 VSS.n2756 VSS.n2427 0.00797475
R4944 VSS.n2317 VSS.n2316 0.00797324
R4945 VSS.n2321 VSS.n2320 0.00797324
R4946 VSS.n2172 VSS.n2171 0.00797324
R4947 VSS.n2176 VSS.n2175 0.00797324
R4948 VSS.n2074 VSS.n1752 0.0079118
R4949 VSS.n2076 VSS.n2072 0.0079118
R4950 VSS.n1734 VSS.n1708 0.0078743
R4951 VSS.n2859 VSS.n2858 0.0078743
R4952 VSS.n1585 VSS.n1573 0.00783036
R4953 VSS.n1564 VSS.n183 0.00778477
R4954 VSS.n1289 VSS.n1285 0.00778477
R4955 VSS.n2325 VSS.n2324 0.00773866
R4956 VSS.n1950 VSS.n1767 0.00772067
R4957 VSS.n1735 VSS.n1707 0.00772067
R4958 VSS.n2057 VSS.n2028 0.00772067
R4959 VSS.n2852 VSS.n2345 0.00772067
R4960 VSS.n782 VSS.n781 0.00767391
R4961 VSS.n1648 VSS.n1647 0.00767391
R4962 VSS.n1402 VSS.n1400 0.00760265
R4963 VSS.n1405 VSS.n1404 0.00760265
R4964 VSS.n1965 VSS.n1768 0.00756704
R4965 VSS.n2056 VSS.n2027 0.00756704
R4966 VSS.n2910 VSS.n2909 0.00745402
R4967 VSS.n1949 VSS.n1769 0.00741341
R4968 VSS.n1736 VSS.n1706 0.00741341
R4969 VSS.n2055 VSS.n2026 0.00741341
R4970 VSS.n2855 VSS.n2854 0.00741341
R4971 VSS.n2872 VSS.n1691 0.00740012
R4972 VSS.n1160 VSS.n1159 0.007375
R4973 VSS.n1147 VSS.n1146 0.007375
R4974 VSS.n229 VSS.n206 0.00737192
R4975 VSS.n211 VSS.n188 0.00737192
R4976 VSS.n1459 VSS.n1408 0.00737192
R4977 VSS.n1451 VSS.n1429 0.00728079
R4978 VSS.n1451 VSS.n1428 0.00728079
R4979 VSS.n1966 VSS.n1770 0.00725978
R4980 VSS.n1737 VSS.n1705 0.00725978
R4981 VSS.n2054 VSS.n2025 0.00725978
R4982 VSS.n2848 VSS.n2346 0.00725978
R4983 VSS.n910 VSS.n909 0.0072433
R4984 VSS.n922 VSS.n920 0.0072433
R4985 VSS.n216 VSS.n188 0.0071898
R4986 VSS.n1461 VSS.n1407 0.0071898
R4987 VSS.n1462 VSS.n1461 0.0071898
R4988 VSS.n1460 VSS.n1407 0.0071898
R4989 VSS.n230 VSS.n206 0.0071898
R4990 VSS.n217 VSS.n187 0.0071898
R4991 VSS.n1460 VSS.n1459 0.0071898
R4992 VSS.n1457 VSS.n1456 0.0071898
R4993 VSS.n217 VSS.n210 0.00718755
R4994 VSS.n216 VSS.n210 0.00718755
R4995 VSS.n255 VSS.n254 0.0071316
R4996 VSS.n365 VSS.n362 0.0071316
R4997 VSS.n919 VSS.n498 0.00711036
R4998 VSS.n1738 VSS.n1704 0.00710615
R4999 VSS.n2851 VSS.n2850 0.00710615
R5000 VSS.n407 VSS.n72 0.00708501
R5001 VSS.n1227 VSS.n1167 0.00707609
R5002 VSS.n906 VSS.n905 0.00703257
R5003 VSS.n923 VSS.n917 0.00703257
R5004 VSS.n2053 VSS.n2024 0.00695251
R5005 VSS.n1231 VSS.n1230 0.00687681
R5006 VSS.n1223 VSS.n1219 0.00687681
R5007 VSS.n1296 VSS.n233 0.00687417
R5008 VSS.n1297 VSS.n232 0.00687417
R5009 VSS.n1298 VSS.n186 0.00687417
R5010 VSS.n1299 VSS.n185 0.00687417
R5011 VSS.n1464 VSS.n1463 0.00687417
R5012 VSS.n1467 VSS.n1466 0.00687417
R5013 VSS.n1967 VSS.n1772 0.00679888
R5014 VSS.n1739 VSS.n1703 0.00679888
R5015 VSS.n2052 VSS.n2023 0.00679888
R5016 VSS.n1225 VSS.n1224 0.00677831
R5017 VSS.n2327 VSS.n2014 0.00676966
R5018 VSS.n1146 VSS.n1145 0.00669275
R5019 VSS.n263 VSS.n233 0.00669205
R5020 VSS.n1402 VSS.n78 0.00669205
R5021 VSS.n2911 VSS.n496 0.0066889
R5022 VSS.n1957 VSS.n1752 0.00668275
R5023 VSS.n1751 VSS.n1750 0.00668275
R5024 VSS.n2072 VSS.n2071 0.00668275
R5025 VSS.n2336 VSS.n2078 0.00668275
R5026 VSS.n1229 VSS.n1228 0.00667867
R5027 VSS.n1232 VSS.n1007 0.00667754
R5028 VSS.n1222 VSS.n1221 0.00667754
R5029 VSS.n2510 VSS.n2509 0.00665672
R5030 VSS.n1784 VSS.n1773 0.00664525
R5031 VSS.n1740 VSS.n1702 0.00664525
R5032 VSS.n2051 VSS.n2022 0.00664525
R5033 VSS.n2847 VSS.n2846 0.00664525
R5034 VSS.n1159 VSS.n1133 0.00654526
R5035 VSS.n1157 VSS.n1156 0.00654526
R5036 VSS.n1155 VSS.n1135 0.00654526
R5037 VSS.n1154 VSS.n1139 0.00654526
R5038 VSS.n1140 VSS.n1139 0.00654526
R5039 VSS.n1150 VSS.n1136 0.00654526
R5040 VSS.n1147 VSS.n1137 0.00654526
R5041 VSS.n1296 VSS.n232 0.00650993
R5042 VSS.n1297 VSS.n231 0.00650993
R5043 VSS.n1299 VSS.n186 0.00650993
R5044 VSS.n1467 VSS.n1464 0.00650993
R5045 VSS.n1972 VSS.n1780 0.00649162
R5046 VSS.n1741 VSS.n1701 0.00649162
R5047 VSS.n1749 VSS.n1694 0.00649162
R5048 VSS.n2043 VSS.n2015 0.00649162
R5049 VSS.n2363 VSS.n2348 0.00649162
R5050 VSS.n2869 VSS.n2335 0.00649162
R5051 VSS.n1968 VSS.n1774 0.00633799
R5052 VSS.n1948 VSS.n1947 0.00633799
R5053 VSS.n1742 VSS.n1700 0.00633799
R5054 VSS.n1748 VSS.n1695 0.00633799
R5055 VSS.n2050 VSS.n2021 0.00633799
R5056 VSS.n2366 VSS.n2365 0.00633799
R5057 VSS.n2354 VSS.n2353 0.00633799
R5058 VSS.n2978 VSS.n2977 0.00627543
R5059 VSS.n2976 VSS.n2 0.00627543
R5060 VSS.n2972 VSS.n1 0.00627543
R5061 VSS.n2973 VSS.n2 0.00627543
R5062 VSS.n2969 VSS.n1 0.00627543
R5063 VSS.n2970 VSS.n2968 0.00623744
R5064 VSS.n1971 VSS.n1779 0.00618436
R5065 VSS.n1783 VSS.n1775 0.00618436
R5066 VSS.n1747 VSS.n1696 0.00618436
R5067 VSS.n2044 VSS.n2016 0.00618436
R5068 VSS.n2049 VSS.n2020 0.00618436
R5069 VSS.n2357 VSS.n2351 0.00618436
R5070 VSS.n1512 VSS.n1511 0.00615378
R5071 VSS.n1781 VSS.n1778 0.00603073
R5072 VSS.n1969 VSS.n1776 0.00603073
R5073 VSS.n1743 VSS.n1699 0.00603073
R5074 VSS.n1746 VSS.n1697 0.00603073
R5075 VSS.n2045 VSS.n2017 0.00603073
R5076 VSS.n2048 VSS.n2019 0.00603073
R5077 VSS.n2359 VSS.n2349 0.00603073
R5078 VSS.n2358 VSS.n2355 0.00603073
R5079 VSS.n2842 VSS 0.006
R5080 VSS.n285 VSS.n284 0.00596687
R5081 VSS.n299 VSS.n291 0.00596687
R5082 VSS.n296 VSS.n292 0.00596687
R5083 VSS.n297 VSS.n295 0.00596687
R5084 VSS.n301 VSS.n300 0.00596687
R5085 VSS.n304 VSS.n301 0.00596687
R5086 VSS.n330 VSS.n329 0.00596687
R5087 VSS.n343 VSS.n342 0.00596687
R5088 VSS.n1970 VSS.n1777 0.00587709
R5089 VSS.n1782 VSS.n1777 0.00587709
R5090 VSS.n1744 VSS.n1698 0.00587709
R5091 VSS.n2046 VSS.n2018 0.00587709
R5092 VSS.n2047 VSS.n2018 0.00587709
R5093 VSS.n2362 VSS.n2361 0.00587709
R5094 VSS.n1404 VSS.n1400 0.00578146
R5095 VSS.n1329 VSS.n126 0.00573893
R5096 VSS.n2426 VSS.n2422 0.00573026
R5097 VSS.n1745 VSS.n1698 0.00572346
R5098 VSS.n1745 VSS.n1697 0.00572346
R5099 VSS.n2361 VSS.n2350 0.00572346
R5100 VSS.n2355 VSS.n2350 0.00572346
R5101 VSS.n2426 VSS.n2425 0.00570742
R5102 VSS.n1372 VSS.n334 0.00563554
R5103 VSS.n1370 VSS.n337 0.00563554
R5104 VSS.n1369 VSS.n1368 0.00563554
R5105 VSS.n1389 VSS.n1388 0.00563554
R5106 VSS.n1387 VSS.n352 0.00563554
R5107 VSS.n1386 VSS.n355 0.00563554
R5108 VSS.n1970 VSS.n1778 0.00556983
R5109 VSS.n1782 VSS.n1776 0.00556983
R5110 VSS.n1744 VSS.n1699 0.00556983
R5111 VSS.n2046 VSS.n2017 0.00556983
R5112 VSS.n2047 VSS.n2019 0.00556983
R5113 VSS.n2362 VSS.n2359 0.00556983
R5114 VSS.n1609 VSS.n605 0.0055
R5115 VSS.n836 VSS.n835 0.0055
R5116 VSS.n1781 VSS.n1779 0.0054162
R5117 VSS.n1969 VSS.n1775 0.0054162
R5118 VSS.n1743 VSS.n1700 0.0054162
R5119 VSS.n1746 VSS.n1696 0.0054162
R5120 VSS.n2045 VSS.n2016 0.0054162
R5121 VSS.n2048 VSS.n2020 0.0054162
R5122 VSS.n2365 VSS.n2349 0.0054162
R5123 VSS.n2358 VSS.n2357 0.0054162
R5124 VSS.n2745 VSS.n2521 0.00540148
R5125 VSS.n1391 VSS.n351 0.00538705
R5126 VSS.n1141 VSS 0.00535991
R5127 VSS.n260 VSS.n259 0.00530422
R5128 VSS.n284 VSS.n283 0.00530422
R5129 VSS.n346 VSS.n343 0.00530422
R5130 VSS.n360 VSS.n359 0.00530422
R5131 VSS.n1971 VSS.n1780 0.00526257
R5132 VSS.n1783 VSS.n1774 0.00526257
R5133 VSS.n1747 VSS.n1695 0.00526257
R5134 VSS.n2044 VSS.n2015 0.00526257
R5135 VSS.n2049 VSS.n2021 0.00526257
R5136 VSS.n2353 VSS.n2351 0.00526257
R5137 VSS.n2091 VSS.n2090 0.00510894
R5138 VSS.n1968 VSS.n1773 0.00510894
R5139 VSS.n1742 VSS.n1701 0.00510894
R5140 VSS.n1748 VSS.n1694 0.00510894
R5141 VSS.n2328 VSS.n2327 0.00510894
R5142 VSS.n2050 VSS.n2022 0.00510894
R5143 VSS.n2366 VSS.n2363 0.00510894
R5144 VSS.n2354 VSS.n2335 0.00510894
R5145 VSS.n1165 VSS.n1164 0.00502922
R5146 VSS.n1161 VSS.n1130 0.00502922
R5147 VSS.n1163 VSS.n1130 0.00502922
R5148 VSS.n1166 VSS.n1165 0.00502922
R5149 VSS.n909 VSS.n496 0.00500308
R5150 VSS.n920 VSS.n919 0.00500308
R5151 VSS.n276 VSS.n267 0.00497289
R5152 VSS.n274 VSS.n270 0.00497289
R5153 VSS.n275 VSS.n271 0.00497289
R5154 VSS.n278 VSS.n277 0.00497289
R5155 VSS.n1741 VSS.n1702 0.00495531
R5156 VSS.n2846 VSS.n2348 0.00495531
R5157 VSS.n1784 VSS.n1772 0.00480168
R5158 VSS.n1740 VSS.n1703 0.00480168
R5159 VSS.n2051 VSS.n2023 0.00480168
R5160 VSS.n2847 VSS.n2844 0.00480168
R5161 VSS.n1230 VSS.n1229 0.00478556
R5162 VSS.n1224 VSS.n1223 0.00478556
R5163 VSS.n1567 VSS.n1566 0.00470469
R5164 VSS.n1555 VSS.n1294 0.00470469
R5165 VSS.n1553 VSS.n1552 0.00470469
R5166 VSS.n1551 VSS.n1550 0.00470469
R5167 VSS.n1549 VSS.n1548 0.00470469
R5168 VSS.n1547 VSS.n1546 0.00470469
R5169 VSS.n1545 VSS.n1544 0.00470469
R5170 VSS.n1543 VSS.n1542 0.00470469
R5171 VSS.n1541 VSS.n1540 0.00470469
R5172 VSS.n1539 VSS.n1538 0.00470469
R5173 VSS.n1537 VSS.n1536 0.00470469
R5174 VSS.n1535 VSS.n1534 0.00470469
R5175 VSS.n1533 VSS.n1532 0.00470469
R5176 VSS.n1531 VSS.n1530 0.00470469
R5177 VSS.n1529 VSS.n1528 0.00470469
R5178 VSS.n1524 VSS.n1523 0.00470469
R5179 VSS.n1522 VSS.n1521 0.00470469
R5180 VSS.n1520 VSS.n1519 0.00470469
R5181 VSS.n1518 VSS.n1517 0.00470469
R5182 VSS.n1516 VSS.n1515 0.00470469
R5183 VSS.n1514 VSS.n1513 0.00470469
R5184 VSS.n1967 VSS.n1771 0.00464804
R5185 VSS.n1739 VSS.n1704 0.00464804
R5186 VSS.n2052 VSS.n2024 0.00464804
R5187 VSS.n2850 VSS.n2347 0.00464804
R5188 VSS.n266 VSS.n265 0.00455873
R5189 VSS.n1948 VSS.n1770 0.00449441
R5190 VSS.n2053 VSS.n2025 0.00449441
R5191 VSS.n263 VSS.n178 0.004493
R5192 VSS.n1564 VSS.n1563 0.00443342
R5193 VSS.n1572 VSS.n1285 0.00443342
R5194 VSS.n264 VSS.n263 0.00442857
R5195 VSS.n1295 VSS.n174 0.00436621
R5196 VSS.n1300 VSS.n173 0.00436621
R5197 VSS.n1305 VSS.n166 0.00436621
R5198 VSS.n1306 VSS.n165 0.00436621
R5199 VSS.n1307 VSS.n162 0.00436621
R5200 VSS.n1308 VSS.n161 0.00436621
R5201 VSS.n1313 VSS.n157 0.00436621
R5202 VSS.n1314 VSS.n154 0.00436621
R5203 VSS.n1315 VSS.n153 0.00436621
R5204 VSS.n1316 VSS.n150 0.00436621
R5205 VSS.n1317 VSS.n149 0.00436621
R5206 VSS.n1318 VSS.n146 0.00436621
R5207 VSS.n1319 VSS.n145 0.00436621
R5208 VSS.n1320 VSS.n142 0.00436621
R5209 VSS.n1323 VSS.n138 0.00436621
R5210 VSS.n1324 VSS.n137 0.00436621
R5211 VSS.n1325 VSS.n134 0.00436621
R5212 VSS.n1326 VSS.n133 0.00436621
R5213 VSS.n1327 VSS.n130 0.00436621
R5214 VSS.n1328 VSS.n129 0.00436621
R5215 VSS.n1738 VSS.n1705 0.00434078
R5216 VSS.n2851 VSS.n2848 0.00434078
R5217 VSS.n1310 VSS.n286 0.00431024
R5218 VSS.n1527 VSS.n1526 0.00429778
R5219 VSS.n1966 VSS.n1769 0.00418715
R5220 VSS.n1737 VSS.n1706 0.00418715
R5221 VSS.n2054 VSS.n2026 0.00418715
R5222 VSS.n2854 VSS.n2346 0.00418715
R5223 VSS.n1560 VSS.n1559 0.00416215
R5224 VSS.n1558 VSS.n1557 0.00416215
R5225 VSS.n2908 VSS.n500 0.00414238
R5226 VSS.n886 VSS.n573 0.00414238
R5227 VSS.n871 VSS.n571 0.00414238
R5228 VSS.n869 VSS.n569 0.00414238
R5229 VSS.n866 VSS.n567 0.00414238
R5230 VSS.n864 VSS.n565 0.00414238
R5231 VSS.n862 VSS.n563 0.00414238
R5232 VSS.n860 VSS.n561 0.00414238
R5233 VSS.n858 VSS.n559 0.00414238
R5234 VSS.n855 VSS.n557 0.00414238
R5235 VSS.n854 VSS.n554 0.00414238
R5236 VSS.n852 VSS.n553 0.00414238
R5237 VSS.n850 VSS.n551 0.00414238
R5238 VSS.n848 VSS.n549 0.00414238
R5239 VSS.n846 VSS.n547 0.00414238
R5240 VSS.n844 VSS.n545 0.00414238
R5241 VSS.n842 VSS.n543 0.00414238
R5242 VSS.n840 VSS.n541 0.00414238
R5243 VSS.n838 VSS.n539 0.00414238
R5244 VSS.n78 VSS.n77 0.00411678
R5245 VSS.n1649 VSS.n1648 0.00408696
R5246 VSS.n1949 VSS.n1768 0.00403352
R5247 VSS.n1736 VSS.n1707 0.00403352
R5248 VSS.n2055 VSS.n2027 0.00403352
R5249 VSS.n2855 VSS.n2852 0.00403352
R5250 VSS.n1322 VSS.n1321 0.00399206
R5251 VSS.n1965 VSS.n1767 0.00387989
R5252 VSS.n2056 VSS.n2028 0.00387989
R5253 VSS.n1302 VSS.n170 0.00386735
R5254 VSS.n1303 VSS.n169 0.00386735
R5255 VSS.n279 VSS.n278 0.0038158
R5256 VSS.n1309 VSS.n289 0.0038158
R5257 VSS.n331 VSS.n330 0.0038158
R5258 VSS.n1368 VSS.n338 0.0038158
R5259 VSS.n348 VSS.n347 0.0038158
R5260 VSS.n1385 VSS.n356 0.0038158
R5261 VSS.n362 VSS.n361 0.0038158
R5262 VSS.n359 VSS.n356 0.0038158
R5263 VSS.n1388 VSS.n348 0.0038158
R5264 VSS.n341 VSS.n338 0.0038158
R5265 VSS.n1371 VSS.n331 0.0038158
R5266 VSS.n298 VSS.n289 0.0038158
R5267 VSS.n282 VSS.n279 0.0038158
R5268 VSS.n258 VSS.n255 0.0038158
R5269 VSS.n1374 VSS.n335 0.00381325
R5270 VSS.n2888 VSS.n2887 0.00377815
R5271 VSS.n2885 VSS.n610 0.00377815
R5272 VSS.n2884 VSS.n613 0.00377815
R5273 VSS.n1178 VSS.n1176 0.00377815
R5274 VSS.n1180 VSS.n1179 0.00377815
R5275 VSS.n2810 VSS.n2809 0.0037574
R5276 VSS.n1950 VSS.n1766 0.00372626
R5277 VSS.n1735 VSS.n1708 0.00372626
R5278 VSS.n2057 VSS.n2029 0.00372626
R5279 VSS.n2858 VSS.n2345 0.00372626
R5280 VSS.n2844 VSS.n2843 0.00372626
R5281 VSS.n1567 VSS.n1565 0.00371239
R5282 VSS.n1513 VSS.n1512 0.00371235
R5283 VSS.n1734 VSS.n1709 0.00357263
R5284 VSS.n2859 VSS.n2856 0.00357263
R5285 VSS.n2843 VSS.n2347 0.00357263
R5286 VSS.n2808 VSS.n2807 0.00350683
R5287 VSS.n1183 VSS.n1182 0.00350497
R5288 VSS.n1187 VSS.n1172 0.00350497
R5289 VSS.n1190 VSS.n1189 0.00350497
R5290 VSS.n1194 VSS.n1171 0.00350497
R5291 VSS.n1197 VSS.n1196 0.00350497
R5292 VSS.n1201 VSS.n1170 0.00350497
R5293 VSS.n1204 VSS.n1203 0.00350497
R5294 VSS.n1208 VSS.n1169 0.00350497
R5295 VSS.n1211 VSS.n1210 0.00350497
R5296 VSS.n1215 VSS.n1168 0.00350497
R5297 VSS.n1218 VSS.n1217 0.00350497
R5298 VSS.n1238 VSS.n998 0.00350497
R5299 VSS.n1329 VSS.n129 0.00349403
R5300 VSS.n1258 VSS.n1257 0.00347297
R5301 VSS.n1964 VSS.n1765 0.00341899
R5302 VSS.n1733 VSS.n1710 0.00341899
R5303 VSS.n2058 VSS.n2030 0.00341899
R5304 VSS.n2862 VSS.n2344 0.00341899
R5305 VSS.n2888 VSS.n609 0.00341391
R5306 VSS.n2887 VSS.n610 0.00341391
R5307 VSS.n2885 VSS.n2884 0.00341391
R5308 VSS.n1176 VSS.n613 0.00341391
R5309 VSS.n1179 VSS.n1178 0.00341391
R5310 VSS.n1180 VSS.n1173 0.00341391
R5311 VSS.n1182 VSS.n1175 0.00341391
R5312 VSS.n1187 VSS.n1184 0.00341391
R5313 VSS.n1189 VSS.n1186 0.00341391
R5314 VSS.n1194 VSS.n1191 0.00341391
R5315 VSS.n1196 VSS.n1193 0.00341391
R5316 VSS.n1201 VSS.n1198 0.00341391
R5317 VSS.n1203 VSS.n1200 0.00341391
R5318 VSS.n1208 VSS.n1205 0.00341391
R5319 VSS.n1210 VSS.n1207 0.00341391
R5320 VSS.n1215 VSS.n1212 0.00341391
R5321 VSS.n1217 VSS.n1214 0.00341391
R5322 VSS.n1238 VSS.n1237 0.00341391
R5323 VSS.n1311 VSS.n158 0.00336848
R5324 VSS.n1510 VSS.n1509 0.00334834
R5325 VSS.n1508 VSS.n1507 0.00334834
R5326 VSS.n1506 VSS.n1505 0.00334834
R5327 VSS.n1504 VSS.n1503 0.00334834
R5328 VSS.n1502 VSS.n1501 0.00334834
R5329 VSS.n1499 VSS.n1498 0.00334834
R5330 VSS.n1568 VSS.n1293 0.00334834
R5331 VSS.n1497 VSS.n1496 0.00334834
R5332 VSS.n1495 VSS.n1494 0.00334834
R5333 VSS.n1493 VSS.n1492 0.00334834
R5334 VSS.n1491 VSS.n1490 0.00334834
R5335 VSS.n1489 VSS.n1488 0.00334834
R5336 VSS.n1487 VSS.n1486 0.00334834
R5337 VSS.n1485 VSS.n1484 0.00334834
R5338 VSS.n1483 VSS.n1482 0.00334834
R5339 VSS.n1481 VSS.n1480 0.00334834
R5340 VSS.n1479 VSS.n1478 0.00334834
R5341 VSS.n1477 VSS.n1476 0.00334834
R5342 VSS.n1472 VSS.n1471 0.00334834
R5343 VSS.n1469 VSS.n1468 0.00334834
R5344 VSS.n1401 VSS.n1285 0.00334834
R5345 VSS.n1347 VSS.n1346 0.00332051
R5346 VSS.n1565 VSS.n1564 0.00330548
R5347 VSS.n1951 VSS.n1764 0.00326536
R5348 VSS.n1732 VSS.n1711 0.00326536
R5349 VSS.n2059 VSS.n2031 0.00326536
R5350 VSS.n2863 VSS.n2860 0.00326536
R5351 VSS.n1226 VSS.t49 0.00326382
R5352 VSS.n2806 VSS.n2805 0.00325626
R5353 VSS.n2815 VSS.n2814 0.00325626
R5354 VSS.n2482 VSS.n2481 0.00316791
R5355 VSS.n1330 VSS.n125 0.00311905
R5356 VSS.n1331 VSS.n122 0.00311905
R5357 VSS.n1358 VSS.n121 0.00311905
R5358 VSS.n1359 VSS.n118 0.00311905
R5359 VSS.n1360 VSS.n117 0.00311905
R5360 VSS.n1362 VSS.n114 0.00311905
R5361 VSS.n1364 VSS.n110 0.00311905
R5362 VSS.n1365 VSS.n109 0.00311905
R5363 VSS.n1366 VSS.n106 0.00311905
R5364 VSS.n1367 VSS.n105 0.00311905
R5365 VSS.n1377 VSS.n101 0.00311905
R5366 VSS.n1378 VSS.n98 0.00311905
R5367 VSS.n1379 VSS.n97 0.00311905
R5368 VSS.n1380 VSS.n94 0.00311905
R5369 VSS.n1381 VSS.n93 0.00311905
R5370 VSS.n1382 VSS.n90 0.00311905
R5371 VSS.n1383 VSS.n89 0.00311905
R5372 VSS.n1397 VSS.n82 0.00311905
R5373 VSS.n1398 VSS.n81 0.00311905
R5374 VSS.n1399 VSS.n78 0.00311905
R5375 VSS.n1963 VSS.n1763 0.00311173
R5376 VSS.n2060 VSS.n2032 0.00311173
R5377 VSS.n848 VSS.n547 0.00304967
R5378 VSS.n846 VSS.n545 0.00304967
R5379 VSS.n844 VSS.n543 0.00304967
R5380 VSS.n842 VSS.n541 0.00304967
R5381 VSS.n840 VSS.n539 0.00304967
R5382 VSS.n2817 VSS.n2816 0.00300569
R5383 VSS.n2479 VSS.n2429 0.00296269
R5384 VSS.n1731 VSS.n1712 0.0029581
R5385 VSS.n2865 VSS.n2343 0.0029581
R5386 VSS.n1570 VSS.n1292 0.00294143
R5387 VSS.n251 VSS.n235 0.0028771
R5388 VSS.n382 VSS.n366 0.0028771
R5389 VSS.n1952 VSS.n1762 0.00280447
R5390 VSS.n1730 VSS.n1713 0.00280447
R5391 VSS.n2061 VSS.n2033 0.00280447
R5392 VSS.n2866 VSS.n2864 0.00280447
R5393 VSS.n2465 VSS.n2430 0.00275746
R5394 VSS.n2487 VSS.n2486 0.00275746
R5395 VSS.n2804 VSS.n2803 0.00275513
R5396 VSS.n1394 VSS.n1363 0.0027449
R5397 VSS.n1242 VSS.n989 0.00272973
R5398 VSS.n1962 VSS.n1761 0.00265084
R5399 VSS.n1729 VSS.n1714 0.00265084
R5400 VSS.n2062 VSS.n2034 0.00265084
R5401 VSS.n2342 VSS.n2010 0.00265084
R5402 VSS.n2489 VSS.n2477 0.00255224
R5403 VSS.n1586 VSS.n1585 0.00253453
R5404 VSS.n1157 VSS.n1133 0.00251509
R5405 VSS.n1156 VSS.n1135 0.00251509
R5406 VSS.n1155 VSS.n1154 0.00251509
R5407 VSS.n1140 VSS.n1136 0.00251509
R5408 VSS.n1150 VSS.n1138 0.00251509
R5409 VSS.n1141 VSS.n1137 0.00251509
R5410 VSS.n2802 VSS.n2801 0.00250456
R5411 VSS.n2819 VSS.n2818 0.00250456
R5412 VSS.n1953 VSS.n1760 0.00249721
R5413 VSS.n2063 VSS.n2035 0.00249721
R5414 VSS.n1475 VSS.n1290 0.00239889
R5415 VSS.n1474 VSS.n1291 0.00239889
R5416 VSS.n2464 VSS.n2431 0.00234701
R5417 VSS.n1961 VSS.n1759 0.00234358
R5418 VSS.n1728 VSS.n1715 0.00234358
R5419 VSS.n2064 VSS.n2036 0.00234358
R5420 VSS.n2867 VSS.n2009 0.00234358
R5421 VSS.n1310 VSS.n1309 0.00232229
R5422 VSS.n1374 VSS.n1373 0.00232229
R5423 VSS.t127 VSS.n497 0.00228481
R5424 VSS.n1511 VSS.n1510 0.00226326
R5425 VSS.n1509 VSS.n1508 0.00226326
R5426 VSS.n1507 VSS.n1506 0.00226326
R5427 VSS.n1505 VSS.n1504 0.00226326
R5428 VSS.n1498 VSS.n1292 0.00226326
R5429 VSS.n1569 VSS.n1568 0.00226326
R5430 VSS.n1497 VSS.n1293 0.00226326
R5431 VSS.n1496 VSS.n1495 0.00226326
R5432 VSS.n1494 VSS.n1493 0.00226326
R5433 VSS.n1492 VSS.n1491 0.00226326
R5434 VSS.n1490 VSS.n1489 0.00226326
R5435 VSS.n1488 VSS.n1487 0.00226326
R5436 VSS.n1486 VSS.n1485 0.00226326
R5437 VSS.n1484 VSS.n1483 0.00226326
R5438 VSS.n1482 VSS.n1481 0.00226326
R5439 VSS.n1480 VSS.n1479 0.00226326
R5440 VSS.n1478 VSS.n1477 0.00226326
R5441 VSS.n1476 VSS.n1475 0.00226326
R5442 VSS.n1474 VSS.n1473 0.00226326
R5443 VSS.n1472 VSS.n1470 0.00226326
R5444 VSS.n1471 VSS.n1469 0.00226326
R5445 VSS.n1468 VSS.n1401 0.00226326
R5446 VSS.n2800 VSS.n2799 0.00225399
R5447 VSS.n2821 VSS.n2820 0.00225399
R5448 VSS.n1393 VSS.n1384 0.00224603
R5449 VSS.n1396 VSS.n1395 0.00224603
R5450 VSS.n884 VSS.n500 0.00223013
R5451 VSS.n886 VSS.n885 0.00223013
R5452 VSS.n883 VSS.n871 0.00223013
R5453 VSS.n873 VSS.n869 0.00223013
R5454 VSS.n882 VSS.n866 0.00223013
R5455 VSS.n874 VSS.n864 0.00223013
R5456 VSS.n881 VSS.n862 0.00223013
R5457 VSS.n875 VSS.n860 0.00223013
R5458 VSS.n880 VSS.n858 0.00223013
R5459 VSS.n876 VSS.n855 0.00223013
R5460 VSS.n879 VSS.n854 0.00223013
R5461 VSS.n877 VSS.n852 0.00223013
R5462 VSS.n878 VSS.n850 0.00223013
R5463 VSS.n1727 VSS.n1716 0.00218994
R5464 VSS.n2341 VSS.n2084 0.00218994
R5465 VSS.n2461 VSS.n2432 0.00214179
R5466 VSS.n2491 VSS.n2490 0.00214179
R5467 VSS VSS.n1502 0.00212762
R5468 VSS.n1330 VSS.n126 0.00212132
R5469 VSS.n1331 VSS.n125 0.00212132
R5470 VSS.n1359 VSS.n121 0.00212132
R5471 VSS.n1360 VSS.n118 0.00212132
R5472 VSS.n1363 VSS.n114 0.00212132
R5473 VSS.n1364 VSS.n113 0.00212132
R5474 VSS.n1365 VSS.n110 0.00212132
R5475 VSS.n1366 VSS.n109 0.00212132
R5476 VSS.n1367 VSS.n106 0.00212132
R5477 VSS.n1376 VSS.n105 0.00212132
R5478 VSS.n1376 VSS.n1375 0.00212132
R5479 VSS.n1377 VSS.n102 0.00212132
R5480 VSS.n1378 VSS.n101 0.00212132
R5481 VSS.n1379 VSS.n98 0.00212132
R5482 VSS.n1380 VSS.n97 0.00212132
R5483 VSS.n1381 VSS.n94 0.00212132
R5484 VSS.n1382 VSS.n93 0.00212132
R5485 VSS.n1383 VSS.n90 0.00212132
R5486 VSS.n1384 VSS.n89 0.00212132
R5487 VSS.n1397 VSS.n85 0.00212132
R5488 VSS.n1398 VSS.n82 0.00212132
R5489 VSS.n1399 VSS.n81 0.00212132
R5490 VSS.n265 VSS.n260 0.0020738
R5491 VSS.n1954 VSS.n1758 0.00203631
R5492 VSS.n1726 VSS.n1717 0.00203631
R5493 VSS.n2065 VSS.n2037 0.00203631
R5494 VSS.n2868 VSS.n2083 0.00203631
R5495 VSS.n2823 VSS.n2822 0.00200342
R5496 VSS.n608 VSS.n605 0.00195695
R5497 VSS.n837 VSS.n836 0.00195695
R5498 VSS.n2460 VSS.n2433 0.00193657
R5499 VSS.n2493 VSS.n2476 0.00193657
R5500 VSS.n2879 VSS.n649 0.00190605
R5501 VSS.n1960 VSS.n1757 0.00188268
R5502 VSS.n1725 VSS.n1718 0.00188268
R5503 VSS.n2066 VSS.n2038 0.00188268
R5504 VSS.n2340 VSS.n2082 0.00188268
R5505 VSS.n1358 VSS.n1357 0.00187188
R5506 VSS.n1500 VSS.n1499 0.00185635
R5507 VSS.n609 VSS.n608 0.00177483
R5508 VSS.n2911 VSS.n2910 0.00176437
R5509 VSS.n2798 VSS.n2797 0.00175285
R5510 VSS.n2825 VSS.n2824 0.00175285
R5511 VSS.n2873 VSS.n1690 0.00175
R5512 VSS.n1362 VSS.n1361 0.00174717
R5513 VSS.n2495 VSS.n2494 0.00173134
R5514 VSS.n1955 VSS.n1756 0.00172905
R5515 VSS.n2067 VSS.n2039 0.00172905
R5516 VSS.n781 VSS.n780 0.00169565
R5517 VSS.n1161 VSS.n1160 0.00168534
R5518 VSS VSS.n1138 0.00168534
R5519 VSS.n1584 VSS.n435 0.00166667
R5520 VSS.n1282 VSS.n448 0.00166667
R5521 VSS.n930 VSS.n929 0.00166667
R5522 VSS.n1606 VSS.n1605 0.00166667
R5523 VSS.n1082 VSS.n671 0.00166667
R5524 VSS.n1162 VSS.n1131 0.00166667
R5525 VSS.n1906 VSS.n1833 0.00166667
R5526 VSS.n276 VSS.n266 0.00165964
R5527 VSS.n274 VSS.n267 0.00165964
R5528 VSS.n275 VSS.n270 0.00165964
R5529 VSS.n277 VSS.n271 0.00165964
R5530 VSS.n1332 VSS.n305 0.00165964
R5531 VSS.n1354 VSS.n326 0.00165964
R5532 VSS.n221 VSS.n198 0.00159272
R5533 VSS.n1433 VSS.n1430 0.00159272
R5534 VSS.n1431 VSS.n1429 0.00159272
R5535 VSS.n1724 VSS.n1719 0.00157542
R5536 VSS.n2339 VSS.n2081 0.00157542
R5537 VSS.n2441 VSS.n2434 0.00152612
R5538 VSS.n2497 VSS.n2475 0.00152612
R5539 VSS.n2785 VSS.n2784 0.00150228
R5540 VSS.n2796 VSS.n2795 0.00150228
R5541 VSS.n2837 VSS.n2404 0.00150228
R5542 VSS.n1167 VSS.n999 0.00150166
R5543 VSS.n1312 VSS.n1311 0.00149773
R5544 VSS.n1375 VSS.n102 0.00149773
R5545 VSS.n1473 VSS.n1290 0.00144945
R5546 VSS.n1470 VSS.n1291 0.00144945
R5547 VSS.n1392 VSS.n86 0.00143537
R5548 VSS.n1944 VSS.n1909 0.00142716
R5549 VSS.n1959 VSS.n1755 0.00142179
R5550 VSS.n1723 VSS.n1720 0.00142179
R5551 VSS.n2068 VSS.n2040 0.00142179
R5552 VSS.n2338 VSS.n2080 0.00142179
R5553 VSS.n222 VSS.n199 0.0014106
R5554 VSS.n207 VSS.n195 0.0014106
R5555 VSS.n1436 VSS.n1434 0.0014106
R5556 VSS.n1428 VSS.n1427 0.0014106
R5557 VSS.n1425 VSS.n1424 0.0014106
R5558 VSS.n1228 VSS.n1227 0.00139674
R5559 VSS.n1393 VSS.n86 0.00137302
R5560 VSS.n1395 VSS.n85 0.00137302
R5561 VSS.n908 VSS.n905 0.00134291
R5562 VSS.n924 VSS.n917 0.00134291
R5563 VSS.n1131 VSS.n1008 0.00133332
R5564 VSS.n930 VSS.n499 0.00133332
R5565 VSS.n474 VSS.n448 0.00133332
R5566 VSS.n435 VSS.n70 0.00133332
R5567 VSS.n2879 VSS.n671 0.00133332
R5568 VSS.n1606 VSS.n474 0.00133332
R5569 VSS.n1906 VSS.n1905 0.00133332
R5570 VSS.n259 VSS.n258 0.00132831
R5571 VSS.n283 VSS.n282 0.00132831
R5572 VSS.n347 VSS.n346 0.00132831
R5573 VSS.n361 VSS.n360 0.00132831
R5574 VSS.n2440 VSS.n2435 0.00132089
R5575 VSS.n2511 VSS.n2510 0.00132089
R5576 VSS.n884 VSS.n573 0.00131954
R5577 VSS.n885 VSS.n571 0.00131954
R5578 VSS.n883 VSS.n569 0.00131954
R5579 VSS.n873 VSS.n567 0.00131954
R5580 VSS.n882 VSS.n565 0.00131954
R5581 VSS.n874 VSS.n563 0.00131954
R5582 VSS.n881 VSS.n561 0.00131954
R5583 VSS.n875 VSS.n559 0.00131954
R5584 VSS.n880 VSS.n557 0.00131954
R5585 VSS.n876 VSS.n554 0.00131954
R5586 VSS.n879 VSS.n553 0.00131954
R5587 VSS.n877 VSS.n551 0.00131954
R5588 VSS.n878 VSS.n549 0.00131954
R5589 VSS.n1233 VSS.n1007 0.0012971
R5590 VSS.n1221 VSS.n1220 0.0012971
R5591 VSS.n1956 VSS.n1754 0.00126816
R5592 VSS.n1722 VSS.n1721 0.00126816
R5593 VSS.n2069 VSS.n2041 0.00126816
R5594 VSS.n2337 VSS.n2079 0.00126816
R5595 VSS.n2794 VSS.n2793 0.00125171
R5596 VSS.n2827 VSS.n2826 0.00125171
R5597 VSS.n2836 VSS.n2835 0.00125171
R5598 VSS.n2873 VSS.n2872 0.00124998
R5599 VSS.n224 VSS.n201 0.00122848
R5600 VSS.n223 VSS.n200 0.00122848
R5601 VSS.n208 VSS.n194 0.00122848
R5602 VSS.n214 VSS.n193 0.00122848
R5603 VSS.n1562 VSS.n184 0.00122848
R5604 VSS.n1441 VSS.n1439 0.00122848
R5605 VSS.n1438 VSS.n1435 0.00122848
R5606 VSS.n1423 VSS.n1422 0.00122848
R5607 VSS.n1420 VSS.n1419 0.00122848
R5608 VSS.n1287 VSS.n1286 0.00122848
R5609 VSS.n1396 VSS.n1392 0.00118594
R5610 VSS.n910 VSS.n906 0.00113218
R5611 VSS.n923 VSS.n922 0.00113218
R5612 VSS.n2753 VSS.n2436 0.00111567
R5613 VSS.n2499 VSS.n2498 0.00111567
R5614 VSS.n2513 VSS.n2512 0.00111567
R5615 VSS.n1947 VSS.n1771 0.00111452
R5616 VSS.n1958 VSS.n1753 0.00111452
R5617 VSS.n2070 VSS.n2042 0.00111452
R5618 VSS.n2520 VSS.n647 0.00110701
R5619 VSS.n1232 VSS.n1231 0.00109783
R5620 VSS.n1222 VSS.n1219 0.00109783
R5621 VSS.n1909 VSS.n1789 0.00105538
R5622 VSS.n226 VSS.n203 0.00104636
R5623 VSS.n225 VSS.n202 0.00104636
R5624 VSS.n213 VSS.n192 0.00104636
R5625 VSS.n1561 VSS.n183 0.00104636
R5626 VSS.n1446 VSS.n1444 0.00104636
R5627 VSS.n1443 VSS.n1440 0.00104636
R5628 VSS.n1418 VSS.n1417 0.00104636
R5629 VSS.n1571 VSS.n1289 0.00104636
R5630 VSS.n2909 VSS.n2908 0.00104636
R5631 VSS.n838 VSS.n837 0.00104636
R5632 VSS.n1560 VSS.n1556 0.00104254
R5633 VSS.n1558 VSS.n1554 0.00104254
R5634 VSS.n1909 VSS.n1791 0.00103709
R5635 VSS.n1909 VSS.n1790 0.00103435
R5636 VSS.n1909 VSS.n1788 0.00103435
R5637 VSS.n1909 VSS.n1787 0.00101041
R5638 VSS.n1115 VSS.n67 0.00100662
R5639 VSS.n1909 VSS.n1785 0.00100554
R5640 VSS.n2787 VSS.n2786 0.00100114
R5641 VSS.n2829 VSS.n2828 0.00100114
R5642 VSS.n2834 VSS.n2833 0.00100114
R5643 VSS.n1690 VSS.n1679 0.001
R5644 VSS.n2861 VSS.n1680 0.001
R5645 VSS.n2857 VSS.n1681 0.001
R5646 VSS.n2853 VSS.n1682 0.001
R5647 VSS.n2849 VSS.n1683 0.001
R5648 VSS.n2845 VSS.n1684 0.001
R5649 VSS.n2364 VSS.n1685 0.001
R5650 VSS.n2360 VSS.n1686 0.001
R5651 VSS.n2356 VSS.n1687 0.001
R5652 VSS.n2352 VSS.n1688 0.001
R5653 VSS.n2334 VSS.n1689 0.001
R5654 VSS.n1902 VSS.n1856 0.001
R5655 VSS.n1904 VSS.n1856 0.001
R5656 VSS.n1129 VSS.n1011 0.001
R5657 VSS.n1162 VSS.n1132 0.001
R5658 VSS.n1158 VSS.n1134 0.001
R5659 VSS.n1153 VSS.n1152 0.001
R5660 VSS.n1151 VSS.n1149 0.001
R5661 VSS.n1148 VSS.n1142 0.001
R5662 VSS.n1144 VSS.n1143 0.001
R5663 VSS.n2750 VSS.n2405 0.001
R5664 VSS.n2443 VSS.n2405 0.001
R5665 VSS.n2444 VSS.n2406 0.001
R5666 VSS.n2445 VSS.n2407 0.001
R5667 VSS.n2446 VSS.n2408 0.001
R5668 VSS.n2447 VSS.n2409 0.001
R5669 VSS.n2448 VSS.n2410 0.001
R5670 VSS.n2449 VSS.n2411 0.001
R5671 VSS.n2450 VSS.n2412 0.001
R5672 VSS.n2451 VSS.n2413 0.001
R5673 VSS.n2452 VSS.n2414 0.001
R5674 VSS.n2453 VSS.n2415 0.001
R5675 VSS.n2454 VSS.n2416 0.001
R5676 VSS.n2455 VSS.n2417 0.001
R5677 VSS.n2456 VSS.n2418 0.001
R5678 VSS.n2457 VSS.n2419 0.001
R5679 VSS.n2458 VSS.n2420 0.001
R5680 VSS.n2423 VSS.n2421 0.001
R5681 VSS.n2760 VSS.n2424 0.001
R5682 VSS.n2439 VSS.n2438 0.001
R5683 VSS.n2754 VSS.n2752 0.001
R5684 VSS.n2459 VSS.n2442 0.001
R5685 VSS.n2463 VSS.n2462 0.001
R5686 VSS.n2467 VSS.n2466 0.001
R5687 VSS.n2480 VSS.n2468 0.001
R5688 VSS.n2484 VSS.n2469 0.001
R5689 VSS.n2488 VSS.n2470 0.001
R5690 VSS.n2492 VSS.n2471 0.001
R5691 VSS.n2496 VSS.n2472 0.001
R5692 VSS.n2500 VSS.n2473 0.001
R5693 VSS.n2519 VSS.n2518 0.001
R5694 VSS.n2428 VSS.t116 0.001
R5695 VSS.n2757 VSS.n2428 0.001
R5696 VSS.n2522 VSS.n2521 0.001
R5697 VSS.n2681 VSS.n2523 0.001
R5698 VSS.n2683 VSS.n2524 0.001
R5699 VSS.n2685 VSS.n2525 0.001
R5700 VSS.n2688 VSS.n2526 0.001
R5701 VSS.n2690 VSS.n2527 0.001
R5702 VSS.n2692 VSS.n2528 0.001
R5703 VSS.n2694 VSS.n2529 0.001
R5704 VSS.n2696 VSS.n2530 0.001
R5705 VSS.n2698 VSS.n2531 0.001
R5706 VSS.n2700 VSS.n2532 0.001
R5707 VSS.n2702 VSS.n2533 0.001
R5708 VSS.n2704 VSS.n2534 0.001
R5709 VSS.n2706 VSS.n2535 0.001
R5710 VSS.n2708 VSS.n2536 0.001
R5711 VSS.n2710 VSS.n2537 0.001
R5712 VSS.n2712 VSS.n2538 0.001
R5713 VSS.n2714 VSS.n2539 0.001
R5714 VSS.n2716 VSS.n2540 0.001
R5715 VSS.n2718 VSS.n2541 0.001
R5716 VSS.n2720 VSS.n2542 0.001
R5717 VSS.n2722 VSS.n2543 0.001
R5718 VSS.n2724 VSS.n2544 0.001
R5719 VSS.n2726 VSS.n2545 0.001
R5720 VSS.n2728 VSS.n2546 0.001
R5721 VSS.n2730 VSS.n2547 0.001
R5722 VSS.n2732 VSS.n2548 0.001
R5723 VSS.n2734 VSS.n2549 0.001
R5724 VSS.n2736 VSS.n2550 0.001
R5725 VSS.n2738 VSS.n2551 0.001
R5726 VSS.n2743 VSS.n2742 0.001
R5727 VSS.n253 VSS.n252 0.001
R5728 VSS.n252 VSS.n236 0.001
R5729 VSS.n250 VSS.n249 0.001
R5730 VSS.n248 VSS.n247 0.001
R5731 VSS.n246 VSS.n245 0.001
R5732 VSS.n244 VSS.n243 0.001
R5733 VSS.n242 VSS.n241 0.001
R5734 VSS.n240 VSS.n239 0.001
R5735 VSS.n238 VSS.n237 0.001
R5736 VSS.n182 VSS.n70 0.001
R5737 VSS.n396 VSS.n73 0.001
R5738 VSS.n396 VSS.n385 0.001
R5739 VSS.n397 VSS.n386 0.001
R5740 VSS.n398 VSS.n387 0.001
R5741 VSS.n399 VSS.n388 0.001
R5742 VSS.n400 VSS.n389 0.001
R5743 VSS.n401 VSS.n390 0.001
R5744 VSS.n402 VSS.n391 0.001
R5745 VSS.n403 VSS.n392 0.001
R5746 VSS.n404 VSS.n393 0.001
R5747 VSS.n405 VSS.n394 0.001
R5748 VSS.n406 VSS.n395 0.001
R5749 VSS.n409 VSS.n408 0.001
R5750 VSS.n1403 VSS.n410 0.001
R5751 VSS.n1455 VSS.n411 0.001
R5752 VSS.n1453 VSS.n412 0.001
R5753 VSS.n1447 VSS.n413 0.001
R5754 VSS.n1442 VSS.n414 0.001
R5755 VSS.n1437 VSS.n415 0.001
R5756 VSS.n1432 VSS.n416 0.001
R5757 VSS.n1426 VSS.n417 0.001
R5758 VSS.n1421 VSS.n418 0.001
R5759 VSS.n1416 VSS.n419 0.001
R5760 VSS.n1411 VSS.n420 0.001
R5761 VSS.n1458 VSS.n421 0.001
R5762 VSS.n1406 VSS.n422 0.001
R5763 VSS.n1465 VSS.n423 0.001
R5764 VSS.n1288 VSS.n424 0.001
R5765 VSS.n1574 VSS.n425 0.001
R5766 VSS.n1575 VSS.n426 0.001
R5767 VSS.n1576 VSS.n427 0.001
R5768 VSS.n1577 VSS.n428 0.001
R5769 VSS.n1578 VSS.n429 0.001
R5770 VSS.n1579 VSS.n430 0.001
R5771 VSS.n1580 VSS.n431 0.001
R5772 VSS.n1581 VSS.n432 0.001
R5773 VSS.n1582 VSS.n433 0.001
R5774 VSS.n1583 VSS.n434 0.001
R5775 VSS.n2918 VSS.n450 0.001
R5776 VSS.n450 VSS.n436 0.001
R5777 VSS.n1260 VSS.n437 0.001
R5778 VSS.n1262 VSS.n438 0.001
R5779 VSS.n1264 VSS.n439 0.001
R5780 VSS.n1266 VSS.n440 0.001
R5781 VSS.n1268 VSS.n441 0.001
R5782 VSS.n1270 VSS.n442 0.001
R5783 VSS.n1272 VSS.n443 0.001
R5784 VSS.n1274 VSS.n444 0.001
R5785 VSS.n1276 VSS.n445 0.001
R5786 VSS.n1278 VSS.n446 0.001
R5787 VSS.n1280 VSS.n447 0.001
R5788 VSS.n932 VSS.n903 0.001
R5789 VSS.n904 VSS.n903 0.001
R5790 VSS.n912 VSS.n911 0.001
R5791 VSS.n914 VSS.n913 0.001
R5792 VSS.n918 VSS.n915 0.001
R5793 VSS.n921 VSS.n916 0.001
R5794 VSS.n2914 VSS.n475 0.001
R5795 VSS.n490 VSS.n475 0.001
R5796 VSS.n2922 VSS.n368 0.001
R5797 VSS.n369 VSS.n368 0.001
R5798 VSS.n381 VSS.n370 0.001
R5799 VSS.n380 VSS.n371 0.001
R5800 VSS.n379 VSS.n372 0.001
R5801 VSS.n378 VSS.n373 0.001
R5802 VSS.n377 VSS.n374 0.001
R5803 VSS.n376 VSS.n375 0.001
R5804 VSS.n384 VSS.n383 0.001
R5805 VSS.n2917 VSS.n452 0.001
R5806 VSS.n1671 VSS.n722 0.001
R5807 VSS.n1671 VSS.n938 0.001
R5808 VSS.n1667 VSS.n940 0.001
R5809 VSS.n1663 VSS.n942 0.001
R5810 VSS.n1659 VSS.n944 0.001
R5811 VSS.n1655 VSS.n946 0.001
R5812 VSS.n1651 VSS.n948 0.001
R5813 VSS.n1646 VSS.n950 0.001
R5814 VSS.n1642 VSS.n952 0.001
R5815 VSS.n1638 VSS.n954 0.001
R5816 VSS.n1634 VSS.n956 0.001
R5817 VSS.n1630 VSS.n958 0.001
R5818 VSS.n1626 VSS.n960 0.001
R5819 VSS.n1622 VSS.n962 0.001
R5820 VSS.n1618 VSS.n964 0.001
R5821 VSS.n1614 VSS.n1608 0.001
R5822 VSS.n1610 VSS.n611 0.001
R5823 VSS.n2886 VSS.n612 0.001
R5824 VSS.n1177 VSS.n966 0.001
R5825 VSS.n1181 VSS.n967 0.001
R5826 VSS.n1188 VSS.n968 0.001
R5827 VSS.n1195 VSS.n969 0.001
R5828 VSS.n1202 VSS.n970 0.001
R5829 VSS.n1209 VSS.n971 0.001
R5830 VSS.n1216 VSS.n972 0.001
R5831 VSS.n1239 VSS.n973 0.001
R5832 VSS.n997 VSS.n974 0.001
R5833 VSS.n996 VSS.n975 0.001
R5834 VSS.n995 VSS.n976 0.001
R5835 VSS.n994 VSS.n977 0.001
R5836 VSS.n993 VSS.n978 0.001
R5837 VSS.n992 VSS.n979 0.001
R5838 VSS.n991 VSS.n980 0.001
R5839 VSS.n1241 VSS.n981 0.001
R5840 VSS.n1243 VSS.n982 0.001
R5841 VSS.n1245 VSS.n983 0.001
R5842 VSS.n1247 VSS.n984 0.001
R5843 VSS.n1249 VSS.n985 0.001
R5844 VSS.n1251 VSS.n986 0.001
R5845 VSS.n1253 VSS.n987 0.001
R5846 VSS.n1255 VSS.n988 0.001
R5847 VSS.t33 VSS.n209 0.001
R5848 VSS.n218 VSS.n209 0.001
R5849 VSS.n2926 VSS.n182 0.001
R5850 VSS.n933 VSS.n587 0.001
R5851 VSS.n590 VSS.n501 0.001
R5852 VSS.n616 VSS.n590 0.001
R5853 VSS.n617 VSS.n591 0.001
R5854 VSS.n618 VSS.n592 0.001
R5855 VSS.n619 VSS.n593 0.001
R5856 VSS.n620 VSS.n594 0.001
R5857 VSS.n621 VSS.n595 0.001
R5858 VSS.n622 VSS.n596 0.001
R5859 VSS.n623 VSS.n597 0.001
R5860 VSS.n624 VSS.n598 0.001
R5861 VSS.n625 VSS.n599 0.001
R5862 VSS.n626 VSS.n600 0.001
R5863 VSS.n627 VSS.n601 0.001
R5864 VSS.n628 VSS.n602 0.001
R5865 VSS.n629 VSS.n603 0.001
R5866 VSS.n606 VSS.n604 0.001
R5867 VSS.n2889 VSS.n607 0.001
R5868 VSS.n2883 VSS.n2882 0.001
R5869 VSS.n630 VSS.n614 0.001
R5870 VSS.n1174 VSS.n631 0.001
R5871 VSS.n1185 VSS.n632 0.001
R5872 VSS.n1192 VSS.n633 0.001
R5873 VSS.n1199 VSS.n634 0.001
R5874 VSS.n1206 VSS.n635 0.001
R5875 VSS.n1213 VSS.n636 0.001
R5876 VSS.n1236 VSS.n637 0.001
R5877 VSS.n1006 VSS.n638 0.001
R5878 VSS.n1005 VSS.n639 0.001
R5879 VSS.n1004 VSS.n640 0.001
R5880 VSS.n1003 VSS.n641 0.001
R5881 VSS.n1002 VSS.n642 0.001
R5882 VSS.n1001 VSS.n643 0.001
R5883 VSS.n1000 VSS.n644 0.001
R5884 VSS.n2907 VSS.n587 0.001
R5885 VSS.n1917 VSS.n1909 0.001
R5886 VSS.n1919 VSS.n1918 0.001
R5887 VSS.n1920 VSS.n1915 0.001
R5888 VSS.n1924 VSS.n1923 0.001
R5889 VSS.n1926 VSS.n1925 0.001
R5890 VSS.n1927 VSS.n1913 0.001
R5891 VSS.n1931 VSS.n1930 0.001
R5892 VSS.n1933 VSS.n1932 0.001
R5893 VSS.n1934 VSS.n1911 0.001
R5894 VSS.n1938 VSS.n1937 0.001
R5895 VSS.n1940 VSS.n1939 0.001
R5896 VSS.n1942 VSS.n1941 0.001
R5897 VSS.n1918 VSS.n1917 0.001
R5898 VSS.n1920 VSS.n1919 0.001
R5899 VSS.n1923 VSS.n1915 0.001
R5900 VSS.n1925 VSS.n1924 0.001
R5901 VSS.n1927 VSS.n1926 0.001
R5902 VSS.n1930 VSS.n1913 0.001
R5903 VSS.n1932 VSS.n1931 0.001
R5904 VSS.n1934 VSS.n1933 0.001
R5905 VSS.n1937 VSS.n1911 0.001
R5906 VSS.n1939 VSS.n1938 0.001
R5907 VSS.n1942 VSS.n1940 0.001
R5908 VSS.n1941 VSS.n1909 0.001
R5909 VSS.n2923 VSS.n2922 0.001
R5910 VSS.n2914 VSS.n2913 0.001
R5911 VSS.n2913 VSS.n490 0.001
R5912 VSS.n933 VSS.n932 0.001
R5913 VSS.n911 VSS.n904 0.001
R5914 VSS.n913 VSS.n912 0.001
R5915 VSS.n918 VSS.n914 0.001
R5916 VSS.n921 VSS.n915 0.001
R5917 VSS.n929 VSS.n916 0.001
R5918 VSS.n2918 VSS.n2917 0.001
R5919 VSS.n1675 VSS.n452 0.001
R5920 VSS.n1260 VSS.n436 0.001
R5921 VSS.n1262 VSS.n437 0.001
R5922 VSS.n1264 VSS.n438 0.001
R5923 VSS.n1266 VSS.n439 0.001
R5924 VSS.n1268 VSS.n440 0.001
R5925 VSS.n1270 VSS.n441 0.001
R5926 VSS.n1272 VSS.n442 0.001
R5927 VSS.n1274 VSS.n443 0.001
R5928 VSS.n1276 VSS.n444 0.001
R5929 VSS.n1278 VSS.n445 0.001
R5930 VSS.n1280 VSS.n446 0.001
R5931 VSS.n1282 VSS.n447 0.001
R5932 VSS.n2926 VSS.n73 0.001
R5933 VSS.n1584 VSS.n434 0.001
R5934 VSS.n1583 VSS.n433 0.001
R5935 VSS.n1582 VSS.n432 0.001
R5936 VSS.n1581 VSS.n431 0.001
R5937 VSS.n1580 VSS.n430 0.001
R5938 VSS.n1579 VSS.n429 0.001
R5939 VSS.n1578 VSS.n428 0.001
R5940 VSS.n1577 VSS.n427 0.001
R5941 VSS.n1576 VSS.n426 0.001
R5942 VSS.n1575 VSS.n425 0.001
R5943 VSS.n1574 VSS.n424 0.001
R5944 VSS.n1288 VSS.n423 0.001
R5945 VSS.n1465 VSS.n422 0.001
R5946 VSS.n1406 VSS.n421 0.001
R5947 VSS.n1458 VSS.n420 0.001
R5948 VSS.n1411 VSS.n419 0.001
R5949 VSS.n1416 VSS.n418 0.001
R5950 VSS.n1421 VSS.n417 0.001
R5951 VSS.n1426 VSS.n416 0.001
R5952 VSS.n1432 VSS.n415 0.001
R5953 VSS.n1437 VSS.n414 0.001
R5954 VSS.n1442 VSS.n413 0.001
R5955 VSS.n1447 VSS.n412 0.001
R5956 VSS.n1453 VSS.n411 0.001
R5957 VSS.n1455 VSS.n410 0.001
R5958 VSS.n1403 VSS.n409 0.001
R5959 VSS.n408 VSS.n395 0.001
R5960 VSS.n406 VSS.n394 0.001
R5961 VSS.n405 VSS.n393 0.001
R5962 VSS.n404 VSS.n392 0.001
R5963 VSS.n403 VSS.n391 0.001
R5964 VSS.n402 VSS.n390 0.001
R5965 VSS.n401 VSS.n389 0.001
R5966 VSS.n400 VSS.n388 0.001
R5967 VSS.n399 VSS.n387 0.001
R5968 VSS.n398 VSS.n386 0.001
R5969 VSS.n397 VSS.n385 0.001
R5970 VSS.n2923 VSS.n253 0.001
R5971 VSS.n250 VSS.n236 0.001
R5972 VSS.n249 VSS.n248 0.001
R5973 VSS.n247 VSS.n246 0.001
R5974 VSS.n245 VSS.n244 0.001
R5975 VSS.n243 VSS.n242 0.001
R5976 VSS.n241 VSS.n240 0.001
R5977 VSS.n239 VSS.n238 0.001
R5978 VSS.n383 VSS.n375 0.001
R5979 VSS.n376 VSS.n374 0.001
R5980 VSS.n377 VSS.n373 0.001
R5981 VSS.n378 VSS.n372 0.001
R5982 VSS.n379 VSS.n371 0.001
R5983 VSS.n380 VSS.n370 0.001
R5984 VSS.n381 VSS.n369 0.001
R5985 VSS.n384 VSS.n234 0.001
R5986 VSS.n237 VSS.n234 0.001
R5987 VSS.n1116 VSS.n1053 0.001
R5988 VSS.n1053 VSS.n1024 0.001
R5989 VSS.n1054 VSS.n1025 0.001
R5990 VSS.n1055 VSS.n1026 0.001
R5991 VSS.n1056 VSS.n1027 0.001
R5992 VSS.n1057 VSS.n1028 0.001
R5993 VSS.n1058 VSS.n1029 0.001
R5994 VSS.n1059 VSS.n1030 0.001
R5995 VSS.n1060 VSS.n1031 0.001
R5996 VSS.n1061 VSS.n1032 0.001
R5997 VSS.n1062 VSS.n1033 0.001
R5998 VSS.n1063 VSS.n1034 0.001
R5999 VSS.n1064 VSS.n1035 0.001
R6000 VSS.n1065 VSS.n1036 0.001
R6001 VSS.n1066 VSS.n1037 0.001
R6002 VSS.n1067 VSS.n1038 0.001
R6003 VSS.n1068 VSS.n1039 0.001
R6004 VSS.n1069 VSS.n1040 0.001
R6005 VSS.n1070 VSS.n1041 0.001
R6006 VSS.n1071 VSS.n1042 0.001
R6007 VSS.n1072 VSS.n1043 0.001
R6008 VSS.n1073 VSS.n1044 0.001
R6009 VSS.n1074 VSS.n1045 0.001
R6010 VSS.n1075 VSS.n1046 0.001
R6011 VSS.n1076 VSS.n1047 0.001
R6012 VSS.n1077 VSS.n1048 0.001
R6013 VSS.n1078 VSS.n1049 0.001
R6014 VSS.n1079 VSS.n1050 0.001
R6015 VSS.n1080 VSS.n1051 0.001
R6016 VSS.n1081 VSS.n1052 0.001
R6017 VSS.n1115 VSS.n650 0.001
R6018 VSS.n2879 VSS.n650 0.001
R6019 VSS.n2681 VSS.n2522 0.001
R6020 VSS.n2683 VSS.n2523 0.001
R6021 VSS.n2685 VSS.n2524 0.001
R6022 VSS.n2688 VSS.n2525 0.001
R6023 VSS.n2690 VSS.n2526 0.001
R6024 VSS.n2692 VSS.n2527 0.001
R6025 VSS.n2694 VSS.n2528 0.001
R6026 VSS.n2696 VSS.n2529 0.001
R6027 VSS.n2698 VSS.n2530 0.001
R6028 VSS.n2700 VSS.n2531 0.001
R6029 VSS.n2702 VSS.n2532 0.001
R6030 VSS.n2704 VSS.n2533 0.001
R6031 VSS.n2706 VSS.n2534 0.001
R6032 VSS.n2708 VSS.n2535 0.001
R6033 VSS.n2710 VSS.n2536 0.001
R6034 VSS.n2712 VSS.n2537 0.001
R6035 VSS.n2714 VSS.n2538 0.001
R6036 VSS.n2716 VSS.n2539 0.001
R6037 VSS.n2718 VSS.n2540 0.001
R6038 VSS.n2720 VSS.n2541 0.001
R6039 VSS.n2722 VSS.n2542 0.001
R6040 VSS.n2724 VSS.n2543 0.001
R6041 VSS.n2726 VSS.n2544 0.001
R6042 VSS.n2728 VSS.n2545 0.001
R6043 VSS.n2730 VSS.n2546 0.001
R6044 VSS.n2732 VSS.n2547 0.001
R6045 VSS.n2734 VSS.n2548 0.001
R6046 VSS.n2736 VSS.n2549 0.001
R6047 VSS.n2738 VSS.n2550 0.001
R6048 VSS.n2742 VSS.n2551 0.001
R6049 VSS.n2743 VSS.n646 0.001
R6050 VSS.n2750 VSS.n647 0.001
R6051 VSS.n2443 VSS.n2406 0.001
R6052 VSS.n2444 VSS.n2407 0.001
R6053 VSS.n2445 VSS.n2408 0.001
R6054 VSS.n2446 VSS.n2409 0.001
R6055 VSS.n2447 VSS.n2410 0.001
R6056 VSS.n2448 VSS.n2411 0.001
R6057 VSS.n2449 VSS.n2412 0.001
R6058 VSS.n2450 VSS.n2413 0.001
R6059 VSS.n2451 VSS.n2414 0.001
R6060 VSS.n2452 VSS.n2415 0.001
R6061 VSS.n2453 VSS.n2416 0.001
R6062 VSS.n2454 VSS.n2417 0.001
R6063 VSS.n2455 VSS.n2418 0.001
R6064 VSS.n2456 VSS.n2419 0.001
R6065 VSS.n2457 VSS.n2420 0.001
R6066 VSS.n2458 VSS.n2421 0.001
R6067 VSS.n2760 VSS.n2423 0.001
R6068 VSS.n2438 VSS.n2424 0.001
R6069 VSS.n2754 VSS.n2439 0.001
R6070 VSS.n2752 VSS.n2442 0.001
R6071 VSS.n2462 VSS.n2459 0.001
R6072 VSS.n2466 VSS.n2463 0.001
R6073 VSS.n2480 VSS.n2467 0.001
R6074 VSS.n2484 VSS.n2468 0.001
R6075 VSS.n2488 VSS.n2469 0.001
R6076 VSS.n2492 VSS.n2470 0.001
R6077 VSS.n2496 VSS.n2471 0.001
R6078 VSS.n2500 VSS.n2472 0.001
R6079 VSS.n2518 VSS.n2473 0.001
R6080 VSS.n2519 VSS.n647 0.001
R6081 VSS.n1116 VSS.n1115 0.001
R6082 VSS.n1054 VSS.n1024 0.001
R6083 VSS.n1055 VSS.n1025 0.001
R6084 VSS.n1056 VSS.n1026 0.001
R6085 VSS.n1057 VSS.n1027 0.001
R6086 VSS.n1058 VSS.n1028 0.001
R6087 VSS.n1059 VSS.n1029 0.001
R6088 VSS.n1060 VSS.n1030 0.001
R6089 VSS.n1061 VSS.n1031 0.001
R6090 VSS.n1062 VSS.n1032 0.001
R6091 VSS.n1063 VSS.n1033 0.001
R6092 VSS.n1064 VSS.n1034 0.001
R6093 VSS.n1065 VSS.n1035 0.001
R6094 VSS.n1066 VSS.n1036 0.001
R6095 VSS.n1067 VSS.n1037 0.001
R6096 VSS.n1068 VSS.n1038 0.001
R6097 VSS.n1069 VSS.n1039 0.001
R6098 VSS.n1070 VSS.n1040 0.001
R6099 VSS.n1071 VSS.n1041 0.001
R6100 VSS.n1072 VSS.n1042 0.001
R6101 VSS.n1073 VSS.n1043 0.001
R6102 VSS.n1074 VSS.n1044 0.001
R6103 VSS.n1075 VSS.n1045 0.001
R6104 VSS.n1076 VSS.n1046 0.001
R6105 VSS.n1077 VSS.n1047 0.001
R6106 VSS.n1078 VSS.n1048 0.001
R6107 VSS.n1079 VSS.n1049 0.001
R6108 VSS.n1080 VSS.n1050 0.001
R6109 VSS.n1081 VSS.n1051 0.001
R6110 VSS.n1082 VSS.n1052 0.001
R6111 VSS.n1158 VSS.n1132 0.001
R6112 VSS.n1153 VSS.n1134 0.001
R6113 VSS.n1152 VSS.n1151 0.001
R6114 VSS.n1149 VSS.n1148 0.001
R6115 VSS.n1144 VSS.n1142 0.001
R6116 VSS.n1143 VSS.n1129 0.001
R6117 VSS.n1011 VSS.n1008 0.001
R6118 VSS.n2907 VSS.n501 0.001
R6119 VSS.n616 VSS.n591 0.001
R6120 VSS.n617 VSS.n592 0.001
R6121 VSS.n618 VSS.n593 0.001
R6122 VSS.n619 VSS.n594 0.001
R6123 VSS.n620 VSS.n595 0.001
R6124 VSS.n621 VSS.n596 0.001
R6125 VSS.n622 VSS.n597 0.001
R6126 VSS.n623 VSS.n598 0.001
R6127 VSS.n624 VSS.n599 0.001
R6128 VSS.n625 VSS.n600 0.001
R6129 VSS.n626 VSS.n601 0.001
R6130 VSS.n627 VSS.n602 0.001
R6131 VSS.n628 VSS.n603 0.001
R6132 VSS.n629 VSS.n604 0.001
R6133 VSS.n2889 VSS.n606 0.001
R6134 VSS.n2883 VSS.n607 0.001
R6135 VSS.n2882 VSS.n614 0.001
R6136 VSS.n1174 VSS.n630 0.001
R6137 VSS.n1185 VSS.n631 0.001
R6138 VSS.n1192 VSS.n632 0.001
R6139 VSS.n1199 VSS.n633 0.001
R6140 VSS.n1206 VSS.n634 0.001
R6141 VSS.n1213 VSS.n635 0.001
R6142 VSS.n1236 VSS.n636 0.001
R6143 VSS.n1006 VSS.n637 0.001
R6144 VSS.n1005 VSS.n638 0.001
R6145 VSS.n1004 VSS.n639 0.001
R6146 VSS.n1003 VSS.n640 0.001
R6147 VSS.n1002 VSS.n641 0.001
R6148 VSS.n1001 VSS.n642 0.001
R6149 VSS.n1000 VSS.n643 0.001
R6150 VSS.n644 VSS.n499 0.001
R6151 VSS.n1675 VSS.n722 0.001
R6152 VSS.n1667 VSS.n938 0.001
R6153 VSS.n1663 VSS.n940 0.001
R6154 VSS.n1659 VSS.n942 0.001
R6155 VSS.n1655 VSS.n944 0.001
R6156 VSS.n1651 VSS.n946 0.001
R6157 VSS.n1646 VSS.n948 0.001
R6158 VSS.n1642 VSS.n950 0.001
R6159 VSS.n1638 VSS.n952 0.001
R6160 VSS.n1634 VSS.n954 0.001
R6161 VSS.n1630 VSS.n956 0.001
R6162 VSS.n1626 VSS.n958 0.001
R6163 VSS.n1622 VSS.n960 0.001
R6164 VSS.n1618 VSS.n962 0.001
R6165 VSS.n1614 VSS.n964 0.001
R6166 VSS.n1610 VSS.n1608 0.001
R6167 VSS.n2886 VSS.n611 0.001
R6168 VSS.n1177 VSS.n612 0.001
R6169 VSS.n1181 VSS.n966 0.001
R6170 VSS.n1188 VSS.n967 0.001
R6171 VSS.n1195 VSS.n968 0.001
R6172 VSS.n1202 VSS.n969 0.001
R6173 VSS.n1209 VSS.n970 0.001
R6174 VSS.n1216 VSS.n971 0.001
R6175 VSS.n1239 VSS.n972 0.001
R6176 VSS.n997 VSS.n973 0.001
R6177 VSS.n996 VSS.n974 0.001
R6178 VSS.n995 VSS.n975 0.001
R6179 VSS.n994 VSS.n976 0.001
R6180 VSS.n993 VSS.n977 0.001
R6181 VSS.n992 VSS.n978 0.001
R6182 VSS.n991 VSS.n979 0.001
R6183 VSS.n1241 VSS.n980 0.001
R6184 VSS.n1243 VSS.n981 0.001
R6185 VSS.n1245 VSS.n982 0.001
R6186 VSS.n1247 VSS.n983 0.001
R6187 VSS.n1249 VSS.n984 0.001
R6188 VSS.n1251 VSS.n985 0.001
R6189 VSS.n1253 VSS.n986 0.001
R6190 VSS.n1255 VSS.n987 0.001
R6191 VSS.n1605 VSS.n988 0.001
R6192 VSS.n1902 VSS.n1901 0.001
R6193 VSS.n1901 VSS.n1814 0.001
R6194 VSS.n1898 VSS.n1815 0.001
R6195 VSS.n1896 VSS.n1816 0.001
R6196 VSS.n1894 VSS.n1817 0.001
R6197 VSS.n1892 VSS.n1818 0.001
R6198 VSS.n1890 VSS.n1819 0.001
R6199 VSS.n1888 VSS.n1820 0.001
R6200 VSS.n1886 VSS.n1821 0.001
R6201 VSS.n1884 VSS.n1822 0.001
R6202 VSS.n1882 VSS.n1823 0.001
R6203 VSS.n1880 VSS.n1824 0.001
R6204 VSS.n1878 VSS.n1825 0.001
R6205 VSS.n1876 VSS.n1826 0.001
R6206 VSS.n1874 VSS.n1827 0.001
R6207 VSS.n1872 VSS.n1828 0.001
R6208 VSS.n1870 VSS.n1829 0.001
R6209 VSS.n1868 VSS.n1830 0.001
R6210 VSS.n1866 VSS.n1831 0.001
R6211 VSS.n1864 VSS.n1832 0.001
R6212 VSS.n1833 VSS.n1832 0.001
R6213 VSS.n1864 VSS.n1831 0.001
R6214 VSS.n1866 VSS.n1830 0.001
R6215 VSS.n1868 VSS.n1829 0.001
R6216 VSS.n1870 VSS.n1828 0.001
R6217 VSS.n1872 VSS.n1827 0.001
R6218 VSS.n1874 VSS.n1826 0.001
R6219 VSS.n1876 VSS.n1825 0.001
R6220 VSS.n1878 VSS.n1824 0.001
R6221 VSS.n1880 VSS.n1823 0.001
R6222 VSS.n1882 VSS.n1822 0.001
R6223 VSS.n1884 VSS.n1821 0.001
R6224 VSS.n1886 VSS.n1820 0.001
R6225 VSS.n1888 VSS.n1819 0.001
R6226 VSS.n1890 VSS.n1818 0.001
R6227 VSS.n1892 VSS.n1817 0.001
R6228 VSS.n1894 VSS.n1816 0.001
R6229 VSS.n1896 VSS.n1815 0.001
R6230 VSS.n1898 VSS.n1814 0.001
R6231 VSS.n1905 VSS.n1904 0.001
R6232 VSS.n2872 VSS.n1689 0.001
R6233 VSS.n2334 VSS.n1688 0.001
R6234 VSS.n2352 VSS.n1687 0.001
R6235 VSS.n2356 VSS.n1686 0.001
R6236 VSS.n2360 VSS.n1685 0.001
R6237 VSS.n2364 VSS.n1684 0.001
R6238 VSS.n2845 VSS.n1683 0.001
R6239 VSS.n2849 VSS.n1682 0.001
R6240 VSS.n2853 VSS.n1681 0.001
R6241 VSS.n2857 VSS.n1680 0.001
R6242 VSS.n2861 VSS.n1679 0.001
R6243 VSS.n707 VSS.n646 0.001
R6244 VSS.n2401 VSS.n708 0.001
R6245 VSS.n2399 VSS.n709 0.001
R6246 VSS.n2397 VSS.n710 0.001
R6247 VSS.n2394 VSS.n711 0.001
R6248 VSS.n2392 VSS.n712 0.001
R6249 VSS.n2390 VSS.n713 0.001
R6250 VSS.n2388 VSS.n714 0.001
R6251 VSS.n2382 VSS.n715 0.001
R6252 VSS.n2380 VSS.n716 0.001
R6253 VSS.n2378 VSS.n717 0.001
R6254 VSS.n2375 VSS.n718 0.001
R6255 VSS.n2373 VSS.n719 0.001
R6256 VSS.n2371 VSS.n720 0.001
R6257 VSS.n2369 VSS.n721 0.001
R6258 VSS.n721 VSS.n6 0.001
R6259 VSS.n2369 VSS.n720 0.001
R6260 VSS.n2371 VSS.n719 0.001
R6261 VSS.n2373 VSS.n718 0.001
R6262 VSS.n2375 VSS.n717 0.001
R6263 VSS.n2378 VSS.n716 0.001
R6264 VSS.n2380 VSS.n715 0.001
R6265 VSS.n2382 VSS.n714 0.001
R6266 VSS.n2388 VSS.n713 0.001
R6267 VSS.n2390 VSS.n712 0.001
R6268 VSS.n2392 VSS.n711 0.001
R6269 VSS.n2394 VSS.n710 0.001
R6270 VSS.n2397 VSS.n709 0.001
R6271 VSS.n2399 VSS.n708 0.001
R6272 VSS.n2401 VSS.n707 0.001
R6273 VSS.n2521 VSS.n38 0.001
R6274 VSS.n2678 VSS.n39 0.001
R6275 VSS.n2676 VSS.n40 0.001
R6276 VSS.n2932 VSS.n36 0.001
R6277 VSS.n2933 VSS.n34 0.001
R6278 VSS.n41 VSS.n32 0.001
R6279 VSS.n42 VSS.n31 0.001
R6280 VSS.n43 VSS.n30 0.001
R6281 VSS.n44 VSS.n29 0.001
R6282 VSS.n45 VSS.n28 0.001
R6283 VSS.n46 VSS.n27 0.001
R6284 VSS.n47 VSS.n26 0.001
R6285 VSS.n48 VSS.n25 0.001
R6286 VSS.n49 VSS.n24 0.001
R6287 VSS.n50 VSS.n23 0.001
R6288 VSS.n51 VSS.n22 0.001
R6289 VSS.n52 VSS.n21 0.001
R6290 VSS.n53 VSS.n20 0.001
R6291 VSS.n54 VSS.n19 0.001
R6292 VSS.n55 VSS.n18 0.001
R6293 VSS.n56 VSS.n17 0.001
R6294 VSS.n57 VSS.n16 0.001
R6295 VSS.n58 VSS.n15 0.001
R6296 VSS.n59 VSS.n14 0.001
R6297 VSS.n60 VSS.n13 0.001
R6298 VSS.n61 VSS.n12 0.001
R6299 VSS.n62 VSS.n11 0.001
R6300 VSS.n63 VSS.n10 0.001
R6301 VSS.n64 VSS.n9 0.001
R6302 VSS.n65 VSS.n8 0.001
R6303 VSS.n66 VSS.n7 0.001
R6304 VSS.n66 VSS.n6 0.001
R6305 VSS.n65 VSS.n7 0.001
R6306 VSS.n64 VSS.n8 0.001
R6307 VSS.n63 VSS.n9 0.001
R6308 VSS.n62 VSS.n10 0.001
R6309 VSS.n61 VSS.n11 0.001
R6310 VSS.n60 VSS.n12 0.001
R6311 VSS.n59 VSS.n13 0.001
R6312 VSS.n58 VSS.n14 0.001
R6313 VSS.n57 VSS.n15 0.001
R6314 VSS.n56 VSS.n16 0.001
R6315 VSS.n55 VSS.n17 0.001
R6316 VSS.n54 VSS.n18 0.001
R6317 VSS.n53 VSS.n19 0.001
R6318 VSS.n52 VSS.n20 0.001
R6319 VSS.n51 VSS.n21 0.001
R6320 VSS.n50 VSS.n22 0.001
R6321 VSS.n49 VSS.n23 0.001
R6322 VSS.n48 VSS.n24 0.001
R6323 VSS.n47 VSS.n25 0.001
R6324 VSS.n46 VSS.n26 0.001
R6325 VSS.n45 VSS.n27 0.001
R6326 VSS.n44 VSS.n28 0.001
R6327 VSS.n43 VSS.n29 0.001
R6328 VSS.n42 VSS.n30 0.001
R6329 VSS.n41 VSS.n31 0.001
R6330 VSS.n34 VSS.n32 0.001
R6331 VSS.n2933 VSS.n2932 0.001
R6332 VSS.n40 VSS.n36 0.001
R6333 VSS.n2676 VSS.n39 0.001
R6334 VSS.n2678 VSS.n38 0.001
R6335 VSS.n1302 VSS.n1301 0.000998866
R6336 VSS.n1304 VSS.n1303 0.000998866
R6337 VSS.n1372 VSS.n1371 0.000996988
R6338 VSS.n1373 VSS.n334 0.000996988
R6339 VSS.n1370 VSS.n335 0.000996988
R6340 VSS.n1369 VSS.n337 0.000996988
R6341 VSS.n1389 VSS.n351 0.000996988
R6342 VSS.n1390 VSS.n352 0.000996988
R6343 VSS.n1387 VSS.n355 0.000996988
R6344 VSS.n1386 VSS.n1385 0.000996988
R6345 VSS.n2759 VSS.n2425 0.000910448
R6346 VSS.n2755 VSS.n2437 0.000910448
R6347 VSS.n2501 VSS.n2474 0.000910448
R6348 VSS.n2515 VSS.n2514 0.000910448
R6349 VSS.n1566 VSS.n1294 0.000906905
R6350 VSS.n1556 VSS.n1555 0.000906905
R6351 VSS.n1559 VSS.n1554 0.000906905
R6352 VSS.n1557 VSS.n1553 0.000906905
R6353 VSS.n1552 VSS.n1551 0.000906905
R6354 VSS.n1550 VSS.n1549 0.000906905
R6355 VSS.n1548 VSS.n1547 0.000906905
R6356 VSS.n1546 VSS.n1545 0.000906905
R6357 VSS.n1544 VSS.n1543 0.000906905
R6358 VSS.n1542 VSS.n1541 0.000906905
R6359 VSS.n1540 VSS.n1539 0.000906905
R6360 VSS.n1538 VSS.n1537 0.000906905
R6361 VSS.n1536 VSS.n1535 0.000906905
R6362 VSS.n1534 VSS.n1533 0.000906905
R6363 VSS.n1532 VSS.n1531 0.000906905
R6364 VSS.n1530 VSS.n1529 0.000906905
R6365 VSS.n1528 VSS.n1527 0.000906905
R6366 VSS.n1526 VSS.n1525 0.000906905
R6367 VSS.n1525 VSS.n1524 0.000906905
R6368 VSS.n1523 VSS.n1522 0.000906905
R6369 VSS.n1521 VSS.n1520 0.000906905
R6370 VSS.n1519 VSS.n1518 0.000906905
R6371 VSS.n1517 VSS.n1516 0.000906905
R6372 VSS.n1515 VSS.n1514 0.000906905
R6373 VSS.n1501 VSS.n1500 0.000906905
R6374 VSS.n1570 VSS.n1569 0.000906905
R6375 VSS.n1295 VSS.n177 0.00087415
R6376 VSS.n1300 VSS.n174 0.00087415
R6377 VSS.n1301 VSS.n173 0.00087415
R6378 VSS.n1304 VSS.n170 0.00087415
R6379 VSS.n1305 VSS.n169 0.00087415
R6380 VSS.n1306 VSS.n166 0.00087415
R6381 VSS.n1307 VSS.n165 0.00087415
R6382 VSS.n1308 VSS.n162 0.00087415
R6383 VSS.n1312 VSS.n161 0.00087415
R6384 VSS.n1313 VSS.n158 0.00087415
R6385 VSS.n1314 VSS.n157 0.00087415
R6386 VSS.n1315 VSS.n154 0.00087415
R6387 VSS.n1316 VSS.n153 0.00087415
R6388 VSS.n1317 VSS.n150 0.00087415
R6389 VSS.n1318 VSS.n149 0.00087415
R6390 VSS.n1319 VSS.n146 0.00087415
R6391 VSS.n1320 VSS.n145 0.00087415
R6392 VSS.n1322 VSS.n142 0.00087415
R6393 VSS.n1321 VSS.n141 0.00087415
R6394 VSS.n1323 VSS.n141 0.00087415
R6395 VSS.n1324 VSS.n138 0.00087415
R6396 VSS.n1325 VSS.n137 0.00087415
R6397 VSS.n1326 VSS.n134 0.00087415
R6398 VSS.n1327 VSS.n133 0.00087415
R6399 VSS.n1328 VSS.n130 0.00087415
R6400 VSS.n1361 VSS.n117 0.00087415
R6401 VSS.n1394 VSS.n113 0.00087415
R6402 VSS.n228 VSS.n205 0.000864238
R6403 VSS.n227 VSS.n204 0.000864238
R6404 VSS.n215 VSS.n191 0.000864238
R6405 VSS.n212 VSS.n190 0.000864238
R6406 VSS.n1452 VSS.n1449 0.000864238
R6407 VSS.n1448 VSS.n1445 0.000864238
R6408 VSS.n1415 VSS.n1414 0.000864238
R6409 VSS.n1413 VSS.n1412 0.000864238
R6410 VSS.n264 VSS.n177 0.000811791
R6411 VSS.n1183 VSS.n1173 0.000773179
R6412 VSS.n1175 VSS.n1172 0.000773179
R6413 VSS.n1190 VSS.n1184 0.000773179
R6414 VSS.n1186 VSS.n1171 0.000773179
R6415 VSS.n1197 VSS.n1191 0.000773179
R6416 VSS.n1193 VSS.n1170 0.000773179
R6417 VSS.n1204 VSS.n1198 0.000773179
R6418 VSS.n1200 VSS.n1169 0.000773179
R6419 VSS.n1211 VSS.n1205 0.000773179
R6420 VSS.n1207 VSS.n1168 0.000773179
R6421 VSS.n1218 VSS.n1212 0.000773179
R6422 VSS.n1214 VSS.n998 0.000773179
R6423 VSS.n1237 VSS.n999 0.000773179
R6424 VSS.n2789 VSS.n2788 0.000750569
R6425 VSS.n1357 VSS.n122 0.000749433
R6426 VSS.n1391 VSS.n1390 0.000748494
R6427 VSS.n2909 VSS.n498 0.000710728
R6428 VSS.n1225 VSS.n1167 0.000699275
R6429 VSS.n219 VSS.n189 0.000682119
R6430 VSS.n1454 VSS.n1450 0.000682119
R6431 VSS.n1410 VSS.n1409 0.000682119
R6432 VSS.n286 VSS.n285 0.000665663
R6433 VSS.n299 VSS.n298 0.000665663
R6434 VSS.n296 VSS.n291 0.000665663
R6435 VSS.n297 VSS.n292 0.000665663
R6436 VSS.n300 VSS.n295 0.000665663
R6437 VSS.n305 VSS.n304 0.000665663
R6438 VSS.n329 VSS.n326 0.000665663
R6439 VSS.n342 VSS.n341 0.000665663
R6440 VSS.n1503 VSS 0.000635635
R6441 a_6646_7350.t0 a_6646_7350.t1 50.6164
R6442 a_8732_8406.t0 a_8732_8406.t1 30.628
R6443 IOVDD.n1520 IOVDD.t187 17.0181
R6444 IOVDD.n1520 IOVDD.t184 17.0181
R6445 IOVDD.n1519 IOVDD.t188 17.0181
R6446 IOVDD.n1519 IOVDD.t185 17.0181
R6447 IOVDD.n1518 IOVDD.t183 17.0181
R6448 IOVDD.n1518 IOVDD.t186 17.0181
R6449 IOVDD.n1329 IOVDD.t98 17.0005
R6450 IOVDD.n1328 IOVDD.t98 17.0005
R6451 IOVDD.n1327 IOVDD.t98 17.0005
R6452 IOVDD.n1326 IOVDD.t98 17.0005
R6453 IOVDD.n1325 IOVDD.t98 17.0005
R6454 IOVDD.n1324 IOVDD.t98 17.0005
R6455 IOVDD.n1323 IOVDD.t98 17.0005
R6456 IOVDD.n1322 IOVDD.t98 17.0005
R6457 IOVDD.n1321 IOVDD.t98 17.0005
R6458 IOVDD.n1320 IOVDD.t98 17.0005
R6459 IOVDD.n1319 IOVDD.t98 17.0005
R6460 IOVDD.n1318 IOVDD.t98 17.0005
R6461 IOVDD.n1317 IOVDD.t98 17.0005
R6462 IOVDD.n1316 IOVDD.t98 17.0005
R6463 IOVDD.n1295 IOVDD.t171 17.0005
R6464 IOVDD.n1294 IOVDD.t171 17.0005
R6465 IOVDD.n1293 IOVDD.t171 17.0005
R6466 IOVDD.n1292 IOVDD.t171 17.0005
R6467 IOVDD.n1291 IOVDD.t171 17.0005
R6468 IOVDD.n1290 IOVDD.t171 17.0005
R6469 IOVDD.n1289 IOVDD.t171 17.0005
R6470 IOVDD.n1288 IOVDD.t171 17.0005
R6471 IOVDD.n1287 IOVDD.t171 17.0005
R6472 IOVDD.n1286 IOVDD.t171 17.0005
R6473 IOVDD.n1285 IOVDD.t171 17.0005
R6474 IOVDD.n1284 IOVDD.t171 17.0005
R6475 IOVDD.n1283 IOVDD.t171 17.0005
R6476 IOVDD.n1282 IOVDD.t171 17.0005
R6477 IOVDD.n1329 IOVDD.t99 17.0005
R6478 IOVDD.t99 IOVDD.n1328 17.0005
R6479 IOVDD.t99 IOVDD.n1327 17.0005
R6480 IOVDD.t99 IOVDD.n1326 17.0005
R6481 IOVDD.t99 IOVDD.n1325 17.0005
R6482 IOVDD.t99 IOVDD.n1324 17.0005
R6483 IOVDD.t99 IOVDD.n1323 17.0005
R6484 IOVDD.t99 IOVDD.n1322 17.0005
R6485 IOVDD.t99 IOVDD.n1321 17.0005
R6486 IOVDD.t99 IOVDD.n1320 17.0005
R6487 IOVDD.t99 IOVDD.n1319 17.0005
R6488 IOVDD.t99 IOVDD.n1318 17.0005
R6489 IOVDD.t99 IOVDD.n1317 17.0005
R6490 IOVDD.t99 IOVDD.n1316 17.0005
R6491 IOVDD.n1295 IOVDD.t172 17.0005
R6492 IOVDD.t172 IOVDD.n1294 17.0005
R6493 IOVDD.t172 IOVDD.n1293 17.0005
R6494 IOVDD.t172 IOVDD.n1292 17.0005
R6495 IOVDD.t172 IOVDD.n1291 17.0005
R6496 IOVDD.t172 IOVDD.n1290 17.0005
R6497 IOVDD.t172 IOVDD.n1289 17.0005
R6498 IOVDD.t172 IOVDD.n1288 17.0005
R6499 IOVDD.t172 IOVDD.n1287 17.0005
R6500 IOVDD.t172 IOVDD.n1286 17.0005
R6501 IOVDD.t172 IOVDD.n1285 17.0005
R6502 IOVDD.t172 IOVDD.n1284 17.0005
R6503 IOVDD.t172 IOVDD.n1283 17.0005
R6504 IOVDD.t172 IOVDD.n1282 17.0005
R6505 IOVDD.n1391 IOVDD.t132 17.0005
R6506 IOVDD.n1390 IOVDD.t132 17.0005
R6507 IOVDD.n1389 IOVDD.t132 17.0005
R6508 IOVDD.n1388 IOVDD.t132 17.0005
R6509 IOVDD.n1387 IOVDD.t132 17.0005
R6510 IOVDD.n1386 IOVDD.t132 17.0005
R6511 IOVDD.n1385 IOVDD.t132 17.0005
R6512 IOVDD.n1384 IOVDD.t132 17.0005
R6513 IOVDD.n1383 IOVDD.t132 17.0005
R6514 IOVDD.n1382 IOVDD.t132 17.0005
R6515 IOVDD.n1381 IOVDD.t132 17.0005
R6516 IOVDD.n1380 IOVDD.t132 17.0005
R6517 IOVDD.n1379 IOVDD.t132 17.0005
R6518 IOVDD.n1392 IOVDD.t132 17.0005
R6519 IOVDD.n1357 IOVDD.t54 17.0005
R6520 IOVDD.n1344 IOVDD.t54 17.0005
R6521 IOVDD.n1356 IOVDD.t54 17.0005
R6522 IOVDD.n1345 IOVDD.t54 17.0005
R6523 IOVDD.n1355 IOVDD.t54 17.0005
R6524 IOVDD.n1346 IOVDD.t54 17.0005
R6525 IOVDD.n1354 IOVDD.t54 17.0005
R6526 IOVDD.n1347 IOVDD.t54 17.0005
R6527 IOVDD.n1353 IOVDD.t54 17.0005
R6528 IOVDD.n1348 IOVDD.t54 17.0005
R6529 IOVDD.n1352 IOVDD.t54 17.0005
R6530 IOVDD.n1349 IOVDD.t54 17.0005
R6531 IOVDD.n1351 IOVDD.t54 17.0005
R6532 IOVDD.n1350 IOVDD.t54 17.0005
R6533 IOVDD.t133 IOVDD.n1391 17.0005
R6534 IOVDD.t133 IOVDD.n1390 17.0005
R6535 IOVDD.t133 IOVDD.n1389 17.0005
R6536 IOVDD.t133 IOVDD.n1388 17.0005
R6537 IOVDD.t133 IOVDD.n1387 17.0005
R6538 IOVDD.t133 IOVDD.n1386 17.0005
R6539 IOVDD.t133 IOVDD.n1385 17.0005
R6540 IOVDD.t133 IOVDD.n1384 17.0005
R6541 IOVDD.t133 IOVDD.n1383 17.0005
R6542 IOVDD.t133 IOVDD.n1382 17.0005
R6543 IOVDD.t133 IOVDD.n1381 17.0005
R6544 IOVDD.t133 IOVDD.n1380 17.0005
R6545 IOVDD.t133 IOVDD.n1379 17.0005
R6546 IOVDD.n1392 IOVDD.t133 17.0005
R6547 IOVDD.n1357 IOVDD.t55 17.0005
R6548 IOVDD.t55 IOVDD.n1344 17.0005
R6549 IOVDD.t55 IOVDD.n1356 17.0005
R6550 IOVDD.t55 IOVDD.n1345 17.0005
R6551 IOVDD.t55 IOVDD.n1355 17.0005
R6552 IOVDD.t55 IOVDD.n1346 17.0005
R6553 IOVDD.t55 IOVDD.n1354 17.0005
R6554 IOVDD.t55 IOVDD.n1347 17.0005
R6555 IOVDD.t55 IOVDD.n1353 17.0005
R6556 IOVDD.t55 IOVDD.n1348 17.0005
R6557 IOVDD.t55 IOVDD.n1352 17.0005
R6558 IOVDD.t55 IOVDD.n1349 17.0005
R6559 IOVDD.t55 IOVDD.n1351 17.0005
R6560 IOVDD.t55 IOVDD.n1350 17.0005
R6561 IOVDD.n1398 IOVDD.n1377 17.0005
R6562 IOVDD.n1398 IOVDD.n1376 17.0005
R6563 IOVDD.n1398 IOVDD.n1375 17.0005
R6564 IOVDD.n1398 IOVDD.n1374 17.0005
R6565 IOVDD.n1398 IOVDD.n1373 17.0005
R6566 IOVDD.n1398 IOVDD.n1372 17.0005
R6567 IOVDD.n1398 IOVDD.n1371 17.0005
R6568 IOVDD.n1398 IOVDD.n1370 17.0005
R6569 IOVDD.n1398 IOVDD.n1369 17.0005
R6570 IOVDD.n1398 IOVDD.n1368 17.0005
R6571 IOVDD.n1398 IOVDD.n1367 17.0005
R6572 IOVDD.n1398 IOVDD.n1366 17.0005
R6573 IOVDD.n1398 IOVDD.n1365 17.0005
R6574 IOVDD.n1398 IOVDD.n1360 17.0005
R6575 IOVDD.n1398 IOVDD.n1359 17.0005
R6576 IOVDD.n1398 IOVDD.n1358 17.0005
R6577 IOVDD.n1398 IOVDD.n1342 17.0005
R6578 IOVDD.n1398 IOVDD.n1341 17.0005
R6579 IOVDD.n1398 IOVDD.n1340 17.0005
R6580 IOVDD.n1398 IOVDD.n1339 17.0005
R6581 IOVDD.n1398 IOVDD.n1338 17.0005
R6582 IOVDD.n1398 IOVDD.n1337 17.0005
R6583 IOVDD.n1398 IOVDD.n1336 17.0005
R6584 IOVDD.n1398 IOVDD.n1335 17.0005
R6585 IOVDD.n1398 IOVDD.n1334 17.0005
R6586 IOVDD.n1398 IOVDD.n1333 17.0005
R6587 IOVDD.n1398 IOVDD.n1332 17.0005
R6588 IOVDD.n1398 IOVDD.n1331 17.0005
R6589 IOVDD.n1398 IOVDD.n1315 17.0005
R6590 IOVDD.n1398 IOVDD.n1314 17.0005
R6591 IOVDD.n1398 IOVDD.n1313 17.0005
R6592 IOVDD.n1398 IOVDD.n1312 17.0005
R6593 IOVDD.n1398 IOVDD.n1311 17.0005
R6594 IOVDD.n1398 IOVDD.n1310 17.0005
R6595 IOVDD.n1398 IOVDD.n1309 17.0005
R6596 IOVDD.n1398 IOVDD.n1308 17.0005
R6597 IOVDD.n1398 IOVDD.n1307 17.0005
R6598 IOVDD.n1398 IOVDD.n1306 17.0005
R6599 IOVDD.n1398 IOVDD.n1305 17.0005
R6600 IOVDD.n1398 IOVDD.n1304 17.0005
R6601 IOVDD.n1398 IOVDD.n1302 17.0005
R6602 IOVDD.n1398 IOVDD.n1298 17.0005
R6603 IOVDD.n1398 IOVDD.n1297 17.0005
R6604 IOVDD.n1398 IOVDD.n1281 17.0005
R6605 IOVDD.n1398 IOVDD.n1280 17.0005
R6606 IOVDD.n1398 IOVDD.n1279 17.0005
R6607 IOVDD.n1398 IOVDD.n1278 17.0005
R6608 IOVDD.n1398 IOVDD.n1277 17.0005
R6609 IOVDD.n1398 IOVDD.n1276 17.0005
R6610 IOVDD.n1398 IOVDD.n1275 17.0005
R6611 IOVDD.n1398 IOVDD.n1274 17.0005
R6612 IOVDD.n1398 IOVDD.n1273 17.0005
R6613 IOVDD.n1398 IOVDD.n1272 17.0005
R6614 IOVDD.n1398 IOVDD.n1271 17.0005
R6615 IOVDD.n1398 IOVDD.n1270 17.0005
R6616 IOVDD.n1398 IOVDD.n1269 17.0005
R6617 IOVDD.n1024 IOVDD.t27 17.0005
R6618 IOVDD.n1023 IOVDD.t27 17.0005
R6619 IOVDD.n1021 IOVDD.t27 17.0005
R6620 IOVDD.n1019 IOVDD.t27 17.0005
R6621 IOVDD.n1017 IOVDD.t27 17.0005
R6622 IOVDD.n1015 IOVDD.t27 17.0005
R6623 IOVDD.n1013 IOVDD.t27 17.0005
R6624 IOVDD.n1011 IOVDD.t27 17.0005
R6625 IOVDD.n1009 IOVDD.t27 17.0005
R6626 IOVDD.n1007 IOVDD.t27 17.0005
R6627 IOVDD.n1005 IOVDD.t27 17.0005
R6628 IOVDD.n1003 IOVDD.t27 17.0005
R6629 IOVDD.n1001 IOVDD.t27 17.0005
R6630 IOVDD.n995 IOVDD.t27 17.0005
R6631 IOVDD.n993 IOVDD.t27 17.0005
R6632 IOVDD.n991 IOVDD.t27 17.0005
R6633 IOVDD.n989 IOVDD.t27 17.0005
R6634 IOVDD.n987 IOVDD.t27 17.0005
R6635 IOVDD.n985 IOVDD.t27 17.0005
R6636 IOVDD.n983 IOVDD.t27 17.0005
R6637 IOVDD.n981 IOVDD.t27 17.0005
R6638 IOVDD.n979 IOVDD.t27 17.0005
R6639 IOVDD.n977 IOVDD.t27 17.0005
R6640 IOVDD.n975 IOVDD.t27 17.0005
R6641 IOVDD.n973 IOVDD.t27 17.0005
R6642 IOVDD.n971 IOVDD.t27 17.0005
R6643 IOVDD.n969 IOVDD.t27 17.0005
R6644 IOVDD.n1413 IOVDD.t7 17.0005
R6645 IOVDD.n1029 IOVDD.t7 17.0005
R6646 IOVDD.n1031 IOVDD.t7 17.0005
R6647 IOVDD.n1033 IOVDD.t7 17.0005
R6648 IOVDD.n1035 IOVDD.t7 17.0005
R6649 IOVDD.n1037 IOVDD.t7 17.0005
R6650 IOVDD.n1039 IOVDD.t7 17.0005
R6651 IOVDD.n1041 IOVDD.t7 17.0005
R6652 IOVDD.n1043 IOVDD.t7 17.0005
R6653 IOVDD.n1045 IOVDD.t7 17.0005
R6654 IOVDD.n1047 IOVDD.t7 17.0005
R6655 IOVDD.n1049 IOVDD.t7 17.0005
R6656 IOVDD.n1051 IOVDD.t7 17.0005
R6657 IOVDD.n1053 IOVDD.t7 17.0005
R6658 IOVDD.n1055 IOVDD.t7 17.0005
R6659 IOVDD.n1057 IOVDD.t7 17.0005
R6660 IOVDD.n1059 IOVDD.t7 17.0005
R6661 IOVDD.n1061 IOVDD.t7 17.0005
R6662 IOVDD.n1063 IOVDD.t7 17.0005
R6663 IOVDD.n1065 IOVDD.t7 17.0005
R6664 IOVDD.n1067 IOVDD.t7 17.0005
R6665 IOVDD.n1069 IOVDD.t7 17.0005
R6666 IOVDD.n1071 IOVDD.t7 17.0005
R6667 IOVDD.n1073 IOVDD.t7 17.0005
R6668 IOVDD.n1075 IOVDD.t7 17.0005
R6669 IOVDD.n1077 IOVDD.t7 17.0005
R6670 IOVDD.n1079 IOVDD.t7 17.0005
R6671 IOVDD.n1081 IOVDD.t7 17.0005
R6672 IOVDD.n1412 IOVDD.t7 17.0005
R6673 IOVDD.t38 IOVDD.n1412 17.0005
R6674 IOVDD.t38 IOVDD.n1081 17.0005
R6675 IOVDD.t38 IOVDD.n1079 17.0005
R6676 IOVDD.t38 IOVDD.n1077 17.0005
R6677 IOVDD.t38 IOVDD.n1075 17.0005
R6678 IOVDD.t38 IOVDD.n1073 17.0005
R6679 IOVDD.t38 IOVDD.n1071 17.0005
R6680 IOVDD.t38 IOVDD.n1069 17.0005
R6681 IOVDD.t38 IOVDD.n1067 17.0005
R6682 IOVDD.t38 IOVDD.n1065 17.0005
R6683 IOVDD.t38 IOVDD.n1063 17.0005
R6684 IOVDD.t38 IOVDD.n1061 17.0005
R6685 IOVDD.t38 IOVDD.n1059 17.0005
R6686 IOVDD.t38 IOVDD.n1057 17.0005
R6687 IOVDD.t38 IOVDD.n1055 17.0005
R6688 IOVDD.t38 IOVDD.n1053 17.0005
R6689 IOVDD.t38 IOVDD.n1051 17.0005
R6690 IOVDD.t38 IOVDD.n1049 17.0005
R6691 IOVDD.t38 IOVDD.n1047 17.0005
R6692 IOVDD.t38 IOVDD.n1045 17.0005
R6693 IOVDD.t38 IOVDD.n1043 17.0005
R6694 IOVDD.t38 IOVDD.n1041 17.0005
R6695 IOVDD.t38 IOVDD.n1039 17.0005
R6696 IOVDD.t38 IOVDD.n1037 17.0005
R6697 IOVDD.t38 IOVDD.n1035 17.0005
R6698 IOVDD.t38 IOVDD.n1033 17.0005
R6699 IOVDD.t38 IOVDD.n1031 17.0005
R6700 IOVDD.t38 IOVDD.n1029 17.0005
R6701 IOVDD.n1413 IOVDD.t38 17.0005
R6702 IOVDD.n1024 IOVDD.t169 17.0005
R6703 IOVDD.t169 IOVDD.n1023 17.0005
R6704 IOVDD.t169 IOVDD.n1021 17.0005
R6705 IOVDD.t169 IOVDD.n1019 17.0005
R6706 IOVDD.t169 IOVDD.n1017 17.0005
R6707 IOVDD.t169 IOVDD.n1015 17.0005
R6708 IOVDD.t169 IOVDD.n1013 17.0005
R6709 IOVDD.t169 IOVDD.n1011 17.0005
R6710 IOVDD.t169 IOVDD.n1009 17.0005
R6711 IOVDD.t169 IOVDD.n1007 17.0005
R6712 IOVDD.t169 IOVDD.n1005 17.0005
R6713 IOVDD.t169 IOVDD.n1003 17.0005
R6714 IOVDD.t169 IOVDD.n1001 17.0005
R6715 IOVDD.t169 IOVDD.n999 17.0005
R6716 IOVDD.t169 IOVDD.n997 17.0005
R6717 IOVDD.t169 IOVDD.n995 17.0005
R6718 IOVDD.t169 IOVDD.n993 17.0005
R6719 IOVDD.t169 IOVDD.n991 17.0005
R6720 IOVDD.t169 IOVDD.n989 17.0005
R6721 IOVDD.t169 IOVDD.n987 17.0005
R6722 IOVDD.t169 IOVDD.n985 17.0005
R6723 IOVDD.t169 IOVDD.n983 17.0005
R6724 IOVDD.t169 IOVDD.n981 17.0005
R6725 IOVDD.t169 IOVDD.n979 17.0005
R6726 IOVDD.t169 IOVDD.n977 17.0005
R6727 IOVDD.t169 IOVDD.n975 17.0005
R6728 IOVDD.t169 IOVDD.n973 17.0005
R6729 IOVDD.t169 IOVDD.n971 17.0005
R6730 IOVDD.t169 IOVDD.n969 17.0005
R6731 IOVDD.n1418 IOVDD.t83 17.0005
R6732 IOVDD.n1420 IOVDD.t83 17.0005
R6733 IOVDD.n1422 IOVDD.t83 17.0005
R6734 IOVDD.n1424 IOVDD.t83 17.0005
R6735 IOVDD.n1426 IOVDD.t83 17.0005
R6736 IOVDD.n1428 IOVDD.t83 17.0005
R6737 IOVDD.n1430 IOVDD.t83 17.0005
R6738 IOVDD.n1432 IOVDD.t83 17.0005
R6739 IOVDD.n1434 IOVDD.t83 17.0005
R6740 IOVDD.n1436 IOVDD.t83 17.0005
R6741 IOVDD.n1438 IOVDD.t83 17.0005
R6742 IOVDD.n1440 IOVDD.t83 17.0005
R6743 IOVDD.n1442 IOVDD.t83 17.0005
R6744 IOVDD.n1444 IOVDD.t83 17.0005
R6745 IOVDD.n1446 IOVDD.t83 17.0005
R6746 IOVDD.n1448 IOVDD.t83 17.0005
R6747 IOVDD.n1450 IOVDD.t83 17.0005
R6748 IOVDD.n1452 IOVDD.t83 17.0005
R6749 IOVDD.n1454 IOVDD.t83 17.0005
R6750 IOVDD.n1456 IOVDD.t83 17.0005
R6751 IOVDD.n1458 IOVDD.t83 17.0005
R6752 IOVDD.n1460 IOVDD.t83 17.0005
R6753 IOVDD.n1462 IOVDD.t83 17.0005
R6754 IOVDD.n1464 IOVDD.t83 17.0005
R6755 IOVDD.n1466 IOVDD.t83 17.0005
R6756 IOVDD.n1468 IOVDD.t83 17.0005
R6757 IOVDD.n1470 IOVDD.t83 17.0005
R6758 IOVDD.n1472 IOVDD.t83 17.0005
R6759 IOVDD.n1473 IOVDD.t83 17.0005
R6760 IOVDD.t18 IOVDD.n1472 17.0005
R6761 IOVDD.t18 IOVDD.n1470 17.0005
R6762 IOVDD.t18 IOVDD.n1468 17.0005
R6763 IOVDD.t18 IOVDD.n1466 17.0005
R6764 IOVDD.t18 IOVDD.n1464 17.0005
R6765 IOVDD.t18 IOVDD.n1462 17.0005
R6766 IOVDD.t18 IOVDD.n1460 17.0005
R6767 IOVDD.t18 IOVDD.n1458 17.0005
R6768 IOVDD.t18 IOVDD.n1456 17.0005
R6769 IOVDD.t18 IOVDD.n1454 17.0005
R6770 IOVDD.t18 IOVDD.n1452 17.0005
R6771 IOVDD.t18 IOVDD.n1450 17.0005
R6772 IOVDD.t18 IOVDD.n1448 17.0005
R6773 IOVDD.t18 IOVDD.n1446 17.0005
R6774 IOVDD.t18 IOVDD.n1444 17.0005
R6775 IOVDD.t18 IOVDD.n1442 17.0005
R6776 IOVDD.t18 IOVDD.n1440 17.0005
R6777 IOVDD.t18 IOVDD.n1438 17.0005
R6778 IOVDD.t18 IOVDD.n1436 17.0005
R6779 IOVDD.t18 IOVDD.n1434 17.0005
R6780 IOVDD.t18 IOVDD.n1432 17.0005
R6781 IOVDD.t18 IOVDD.n1430 17.0005
R6782 IOVDD.t18 IOVDD.n1428 17.0005
R6783 IOVDD.t18 IOVDD.n1426 17.0005
R6784 IOVDD.t18 IOVDD.n1424 17.0005
R6785 IOVDD.t18 IOVDD.n1422 17.0005
R6786 IOVDD.t18 IOVDD.n1420 17.0005
R6787 IOVDD.t18 IOVDD.n1418 17.0005
R6788 IOVDD.n1473 IOVDD.t18 17.0005
R6789 IOVDD.n1082 IOVDD.n962 17.0005
R6790 IOVDD.n1080 IOVDD.n962 17.0005
R6791 IOVDD.n1078 IOVDD.n962 17.0005
R6792 IOVDD.n1076 IOVDD.n962 17.0005
R6793 IOVDD.n1074 IOVDD.n962 17.0005
R6794 IOVDD.n1072 IOVDD.n962 17.0005
R6795 IOVDD.n1070 IOVDD.n962 17.0005
R6796 IOVDD.n1068 IOVDD.n962 17.0005
R6797 IOVDD.n1066 IOVDD.n962 17.0005
R6798 IOVDD.n1064 IOVDD.n962 17.0005
R6799 IOVDD.n1062 IOVDD.n962 17.0005
R6800 IOVDD.n1060 IOVDD.n962 17.0005
R6801 IOVDD.n1058 IOVDD.n962 17.0005
R6802 IOVDD.n1056 IOVDD.n962 17.0005
R6803 IOVDD.n1054 IOVDD.n962 17.0005
R6804 IOVDD.n1050 IOVDD.n962 17.0005
R6805 IOVDD.n1048 IOVDD.n962 17.0005
R6806 IOVDD.n1046 IOVDD.n962 17.0005
R6807 IOVDD.n1044 IOVDD.n962 17.0005
R6808 IOVDD.n1042 IOVDD.n962 17.0005
R6809 IOVDD.n1040 IOVDD.n962 17.0005
R6810 IOVDD.n1038 IOVDD.n962 17.0005
R6811 IOVDD.n1036 IOVDD.n962 17.0005
R6812 IOVDD.n1034 IOVDD.n962 17.0005
R6813 IOVDD.n1032 IOVDD.n962 17.0005
R6814 IOVDD.n1030 IOVDD.n962 17.0005
R6815 IOVDD.n1028 IOVDD.n962 17.0005
R6816 IOVDD.n1027 IOVDD.n962 17.0005
R6817 IOVDD.n1025 IOVDD.n962 17.0005
R6818 IOVDD.n967 IOVDD.n962 17.0005
R6819 IOVDD.n1022 IOVDD.n962 17.0005
R6820 IOVDD.n1020 IOVDD.n962 17.0005
R6821 IOVDD.n1018 IOVDD.n962 17.0005
R6822 IOVDD.n1016 IOVDD.n962 17.0005
R6823 IOVDD.n1014 IOVDD.n962 17.0005
R6824 IOVDD.n1012 IOVDD.n962 17.0005
R6825 IOVDD.n1010 IOVDD.n962 17.0005
R6826 IOVDD.n1008 IOVDD.n962 17.0005
R6827 IOVDD.n1006 IOVDD.n962 17.0005
R6828 IOVDD.n1004 IOVDD.n962 17.0005
R6829 IOVDD.n1002 IOVDD.n962 17.0005
R6830 IOVDD.n996 IOVDD.n962 17.0005
R6831 IOVDD.n994 IOVDD.n962 17.0005
R6832 IOVDD.n990 IOVDD.n962 17.0005
R6833 IOVDD.n988 IOVDD.n962 17.0005
R6834 IOVDD.n986 IOVDD.n962 17.0005
R6835 IOVDD.n984 IOVDD.n962 17.0005
R6836 IOVDD.n982 IOVDD.n962 17.0005
R6837 IOVDD.n980 IOVDD.n962 17.0005
R6838 IOVDD.n978 IOVDD.n962 17.0005
R6839 IOVDD.n976 IOVDD.n962 17.0005
R6840 IOVDD.n974 IOVDD.n962 17.0005
R6841 IOVDD.n972 IOVDD.n962 17.0005
R6842 IOVDD.n970 IOVDD.n962 17.0005
R6843 IOVDD.n965 IOVDD.n962 17.0005
R6844 IOVDD.n1417 IOVDD.n962 17.0005
R6845 IOVDD.n1419 IOVDD.n962 17.0005
R6846 IOVDD.n1421 IOVDD.n962 17.0005
R6847 IOVDD.n1423 IOVDD.n962 17.0005
R6848 IOVDD.n1425 IOVDD.n962 17.0005
R6849 IOVDD.n1427 IOVDD.n962 17.0005
R6850 IOVDD.n1429 IOVDD.n962 17.0005
R6851 IOVDD.n1431 IOVDD.n962 17.0005
R6852 IOVDD.n1433 IOVDD.n962 17.0005
R6853 IOVDD.n1435 IOVDD.n962 17.0005
R6854 IOVDD.n1437 IOVDD.n962 17.0005
R6855 IOVDD.n1439 IOVDD.n962 17.0005
R6856 IOVDD.n1441 IOVDD.n962 17.0005
R6857 IOVDD.n1443 IOVDD.n962 17.0005
R6858 IOVDD.n1447 IOVDD.n962 17.0005
R6859 IOVDD.n1449 IOVDD.n962 17.0005
R6860 IOVDD.n1451 IOVDD.n962 17.0005
R6861 IOVDD.n1453 IOVDD.n962 17.0005
R6862 IOVDD.n1455 IOVDD.n962 17.0005
R6863 IOVDD.n1457 IOVDD.n962 17.0005
R6864 IOVDD.n1459 IOVDD.n962 17.0005
R6865 IOVDD.n1461 IOVDD.n962 17.0005
R6866 IOVDD.n1463 IOVDD.n962 17.0005
R6867 IOVDD.n1465 IOVDD.n962 17.0005
R6868 IOVDD.n1467 IOVDD.n962 17.0005
R6869 IOVDD.n1469 IOVDD.n962 17.0005
R6870 IOVDD.n1471 IOVDD.n962 17.0005
R6871 IOVDD.n963 IOVDD.n962 17.0005
R6872 IOVDD.n1474 IOVDD.n962 17.0005
R6873 IOVDD.n1180 IOVDD.t6 17.0005
R6874 IOVDD.n1181 IOVDD.t6 17.0005
R6875 IOVDD.n1182 IOVDD.t6 17.0005
R6876 IOVDD.n1183 IOVDD.t6 17.0005
R6877 IOVDD.n1184 IOVDD.t6 17.0005
R6878 IOVDD.n1185 IOVDD.t6 17.0005
R6879 IOVDD.n1186 IOVDD.t6 17.0005
R6880 IOVDD.n1187 IOVDD.t6 17.0005
R6881 IOVDD.n1188 IOVDD.t6 17.0005
R6882 IOVDD.n1189 IOVDD.t6 17.0005
R6883 IOVDD.n1190 IOVDD.t6 17.0005
R6884 IOVDD.n1191 IOVDD.t6 17.0005
R6885 IOVDD.n1192 IOVDD.t6 17.0005
R6886 IOVDD.n1196 IOVDD.t6 17.0005
R6887 IOVDD.n1197 IOVDD.t6 17.0005
R6888 IOVDD.n1198 IOVDD.t6 17.0005
R6889 IOVDD.n1199 IOVDD.t6 17.0005
R6890 IOVDD.n1200 IOVDD.t6 17.0005
R6891 IOVDD.n1201 IOVDD.t6 17.0005
R6892 IOVDD.n1202 IOVDD.t6 17.0005
R6893 IOVDD.n1203 IOVDD.t6 17.0005
R6894 IOVDD.n1204 IOVDD.t6 17.0005
R6895 IOVDD.n1205 IOVDD.t6 17.0005
R6896 IOVDD.n1206 IOVDD.t6 17.0005
R6897 IOVDD.n1207 IOVDD.t6 17.0005
R6898 IOVDD.n1208 IOVDD.t6 17.0005
R6899 IOVDD.n1179 IOVDD.t6 17.0005
R6900 IOVDD.t8 IOVDD.n1092 17.0005
R6901 IOVDD.n1239 IOVDD.t8 17.0005
R6902 IOVDD.n1240 IOVDD.t8 17.0005
R6903 IOVDD.n1241 IOVDD.t8 17.0005
R6904 IOVDD.n1242 IOVDD.t8 17.0005
R6905 IOVDD.n1243 IOVDD.t8 17.0005
R6906 IOVDD.n1244 IOVDD.t8 17.0005
R6907 IOVDD.n1245 IOVDD.t8 17.0005
R6908 IOVDD.n1246 IOVDD.t8 17.0005
R6909 IOVDD.n1247 IOVDD.t8 17.0005
R6910 IOVDD.n1248 IOVDD.t8 17.0005
R6911 IOVDD.n1249 IOVDD.t8 17.0005
R6912 IOVDD.n1250 IOVDD.t8 17.0005
R6913 IOVDD.n1251 IOVDD.t8 17.0005
R6914 IOVDD.n1252 IOVDD.t8 17.0005
R6915 IOVDD.n1253 IOVDD.t8 17.0005
R6916 IOVDD.n1254 IOVDD.t8 17.0005
R6917 IOVDD.n1255 IOVDD.t8 17.0005
R6918 IOVDD.n1256 IOVDD.t8 17.0005
R6919 IOVDD.n1257 IOVDD.t8 17.0005
R6920 IOVDD.n1258 IOVDD.t8 17.0005
R6921 IOVDD.n1259 IOVDD.t8 17.0005
R6922 IOVDD.n1260 IOVDD.t8 17.0005
R6923 IOVDD.n1261 IOVDD.t8 17.0005
R6924 IOVDD.n1262 IOVDD.t8 17.0005
R6925 IOVDD.n1263 IOVDD.t8 17.0005
R6926 IOVDD.n1264 IOVDD.t8 17.0005
R6927 IOVDD.n1265 IOVDD.t8 17.0005
R6928 IOVDD.n1266 IOVDD.t8 17.0005
R6929 IOVDD.n1148 IOVDD.t20 17.0005
R6930 IOVDD.n1123 IOVDD.t20 17.0005
R6931 IOVDD.n1147 IOVDD.t20 17.0005
R6932 IOVDD.n1124 IOVDD.t20 17.0005
R6933 IOVDD.n1146 IOVDD.t20 17.0005
R6934 IOVDD.n1125 IOVDD.t20 17.0005
R6935 IOVDD.n1145 IOVDD.t20 17.0005
R6936 IOVDD.n1126 IOVDD.t20 17.0005
R6937 IOVDD.n1144 IOVDD.t20 17.0005
R6938 IOVDD.n1127 IOVDD.t20 17.0005
R6939 IOVDD.n1143 IOVDD.t20 17.0005
R6940 IOVDD.n1128 IOVDD.t20 17.0005
R6941 IOVDD.n1142 IOVDD.t20 17.0005
R6942 IOVDD.n1129 IOVDD.t20 17.0005
R6943 IOVDD.n1141 IOVDD.t20 17.0005
R6944 IOVDD.n1130 IOVDD.t20 17.0005
R6945 IOVDD.n1140 IOVDD.t20 17.0005
R6946 IOVDD.n1131 IOVDD.t20 17.0005
R6947 IOVDD.n1139 IOVDD.t20 17.0005
R6948 IOVDD.n1132 IOVDD.t20 17.0005
R6949 IOVDD.n1138 IOVDD.t20 17.0005
R6950 IOVDD.n1133 IOVDD.t20 17.0005
R6951 IOVDD.n1137 IOVDD.t20 17.0005
R6952 IOVDD.n1134 IOVDD.t20 17.0005
R6953 IOVDD.n1136 IOVDD.t20 17.0005
R6954 IOVDD.n1135 IOVDD.t20 17.0005
R6955 IOVDD.t20 IOVDD.n1121 17.0005
R6956 IOVDD.n1149 IOVDD.t20 17.0005
R6957 IOVDD.n1122 IOVDD.t20 17.0005
R6958 IOVDD.n1266 IOVDD.t107 17.0005
R6959 IOVDD.t107 IOVDD.n1265 17.0005
R6960 IOVDD.t107 IOVDD.n1264 17.0005
R6961 IOVDD.t107 IOVDD.n1263 17.0005
R6962 IOVDD.t107 IOVDD.n1262 17.0005
R6963 IOVDD.t107 IOVDD.n1261 17.0005
R6964 IOVDD.t107 IOVDD.n1260 17.0005
R6965 IOVDD.t107 IOVDD.n1259 17.0005
R6966 IOVDD.t107 IOVDD.n1258 17.0005
R6967 IOVDD.t107 IOVDD.n1257 17.0005
R6968 IOVDD.t107 IOVDD.n1256 17.0005
R6969 IOVDD.t107 IOVDD.n1255 17.0005
R6970 IOVDD.t107 IOVDD.n1254 17.0005
R6971 IOVDD.t107 IOVDD.n1253 17.0005
R6972 IOVDD.t107 IOVDD.n1252 17.0005
R6973 IOVDD.t107 IOVDD.n1251 17.0005
R6974 IOVDD.t107 IOVDD.n1250 17.0005
R6975 IOVDD.t107 IOVDD.n1249 17.0005
R6976 IOVDD.t107 IOVDD.n1248 17.0005
R6977 IOVDD.t107 IOVDD.n1247 17.0005
R6978 IOVDD.t107 IOVDD.n1246 17.0005
R6979 IOVDD.t107 IOVDD.n1245 17.0005
R6980 IOVDD.t107 IOVDD.n1244 17.0005
R6981 IOVDD.t107 IOVDD.n1243 17.0005
R6982 IOVDD.t107 IOVDD.n1242 17.0005
R6983 IOVDD.t107 IOVDD.n1241 17.0005
R6984 IOVDD.t107 IOVDD.n1240 17.0005
R6985 IOVDD.t107 IOVDD.n1239 17.0005
R6986 IOVDD.t107 IOVDD.n1092 17.0005
R6987 IOVDD.n1208 IOVDD.t88 17.0005
R6988 IOVDD.t88 IOVDD.n1207 17.0005
R6989 IOVDD.t88 IOVDD.n1206 17.0005
R6990 IOVDD.t88 IOVDD.n1205 17.0005
R6991 IOVDD.t88 IOVDD.n1204 17.0005
R6992 IOVDD.t88 IOVDD.n1203 17.0005
R6993 IOVDD.t88 IOVDD.n1202 17.0005
R6994 IOVDD.t88 IOVDD.n1201 17.0005
R6995 IOVDD.t88 IOVDD.n1200 17.0005
R6996 IOVDD.t88 IOVDD.n1199 17.0005
R6997 IOVDD.t88 IOVDD.n1198 17.0005
R6998 IOVDD.t88 IOVDD.n1197 17.0005
R6999 IOVDD.t88 IOVDD.n1196 17.0005
R7000 IOVDD.t88 IOVDD.n1195 17.0005
R7001 IOVDD.t88 IOVDD.n1193 17.0005
R7002 IOVDD.t88 IOVDD.n1192 17.0005
R7003 IOVDD.t88 IOVDD.n1191 17.0005
R7004 IOVDD.t88 IOVDD.n1190 17.0005
R7005 IOVDD.t88 IOVDD.n1189 17.0005
R7006 IOVDD.t88 IOVDD.n1188 17.0005
R7007 IOVDD.t88 IOVDD.n1187 17.0005
R7008 IOVDD.t88 IOVDD.n1186 17.0005
R7009 IOVDD.t88 IOVDD.n1185 17.0005
R7010 IOVDD.t88 IOVDD.n1184 17.0005
R7011 IOVDD.t88 IOVDD.n1183 17.0005
R7012 IOVDD.t88 IOVDD.n1182 17.0005
R7013 IOVDD.t88 IOVDD.n1181 17.0005
R7014 IOVDD.t88 IOVDD.n1180 17.0005
R7015 IOVDD.t88 IOVDD.n1179 17.0005
R7016 IOVDD.t148 IOVDD.n1148 17.0005
R7017 IOVDD.t148 IOVDD.n1123 17.0005
R7018 IOVDD.t148 IOVDD.n1147 17.0005
R7019 IOVDD.t148 IOVDD.n1124 17.0005
R7020 IOVDD.t148 IOVDD.n1146 17.0005
R7021 IOVDD.t148 IOVDD.n1125 17.0005
R7022 IOVDD.t148 IOVDD.n1145 17.0005
R7023 IOVDD.t148 IOVDD.n1126 17.0005
R7024 IOVDD.t148 IOVDD.n1144 17.0005
R7025 IOVDD.t148 IOVDD.n1127 17.0005
R7026 IOVDD.t148 IOVDD.n1143 17.0005
R7027 IOVDD.t148 IOVDD.n1128 17.0005
R7028 IOVDD.t148 IOVDD.n1142 17.0005
R7029 IOVDD.t148 IOVDD.n1129 17.0005
R7030 IOVDD.t148 IOVDD.n1141 17.0005
R7031 IOVDD.t148 IOVDD.n1130 17.0005
R7032 IOVDD.t148 IOVDD.n1140 17.0005
R7033 IOVDD.t148 IOVDD.n1131 17.0005
R7034 IOVDD.t148 IOVDD.n1139 17.0005
R7035 IOVDD.t148 IOVDD.n1132 17.0005
R7036 IOVDD.t148 IOVDD.n1138 17.0005
R7037 IOVDD.t148 IOVDD.n1133 17.0005
R7038 IOVDD.t148 IOVDD.n1137 17.0005
R7039 IOVDD.t148 IOVDD.n1134 17.0005
R7040 IOVDD.t148 IOVDD.n1136 17.0005
R7041 IOVDD.t148 IOVDD.n1135 17.0005
R7042 IOVDD.t148 IOVDD.n1121 17.0005
R7043 IOVDD.n1149 IOVDD.t148 17.0005
R7044 IOVDD.t148 IOVDD.n1122 17.0005
R7045 IOVDD.n1400 IOVDD.n1094 17.0005
R7046 IOVDD.n1400 IOVDD.n1095 17.0005
R7047 IOVDD.n1400 IOVDD.n1096 17.0005
R7048 IOVDD.n1400 IOVDD.n1097 17.0005
R7049 IOVDD.n1400 IOVDD.n1098 17.0005
R7050 IOVDD.n1400 IOVDD.n1099 17.0005
R7051 IOVDD.n1400 IOVDD.n1100 17.0005
R7052 IOVDD.n1400 IOVDD.n1101 17.0005
R7053 IOVDD.n1400 IOVDD.n1102 17.0005
R7054 IOVDD.n1400 IOVDD.n1103 17.0005
R7055 IOVDD.n1400 IOVDD.n1104 17.0005
R7056 IOVDD.n1400 IOVDD.n1105 17.0005
R7057 IOVDD.n1400 IOVDD.n1106 17.0005
R7058 IOVDD.n1400 IOVDD.n1107 17.0005
R7059 IOVDD.n1400 IOVDD.n1109 17.0005
R7060 IOVDD.n1400 IOVDD.n1110 17.0005
R7061 IOVDD.n1400 IOVDD.n1111 17.0005
R7062 IOVDD.n1400 IOVDD.n1112 17.0005
R7063 IOVDD.n1400 IOVDD.n1113 17.0005
R7064 IOVDD.n1400 IOVDD.n1114 17.0005
R7065 IOVDD.n1400 IOVDD.n1115 17.0005
R7066 IOVDD.n1400 IOVDD.n1116 17.0005
R7067 IOVDD.n1400 IOVDD.n1117 17.0005
R7068 IOVDD.n1400 IOVDD.n1118 17.0005
R7069 IOVDD.n1400 IOVDD.n1119 17.0005
R7070 IOVDD.n1400 IOVDD.n1120 17.0005
R7071 IOVDD.n1400 IOVDD.n1150 17.0005
R7072 IOVDD.n1400 IOVDD.n1087 17.0005
R7073 IOVDD.n1400 IOVDD.n1088 17.0005
R7074 IOVDD.n1400 IOVDD.n1152 17.0005
R7075 IOVDD.n1400 IOVDD.n1153 17.0005
R7076 IOVDD.n1400 IOVDD.n1154 17.0005
R7077 IOVDD.n1400 IOVDD.n1155 17.0005
R7078 IOVDD.n1400 IOVDD.n1156 17.0005
R7079 IOVDD.n1400 IOVDD.n1157 17.0005
R7080 IOVDD.n1400 IOVDD.n1158 17.0005
R7081 IOVDD.n1400 IOVDD.n1159 17.0005
R7082 IOVDD.n1400 IOVDD.n1160 17.0005
R7083 IOVDD.n1400 IOVDD.n1161 17.0005
R7084 IOVDD.n1400 IOVDD.n1162 17.0005
R7085 IOVDD.n1400 IOVDD.n1164 17.0005
R7086 IOVDD.n1400 IOVDD.n1165 17.0005
R7087 IOVDD.n1400 IOVDD.n1167 17.0005
R7088 IOVDD.n1400 IOVDD.n1168 17.0005
R7089 IOVDD.n1400 IOVDD.n1169 17.0005
R7090 IOVDD.n1400 IOVDD.n1170 17.0005
R7091 IOVDD.n1400 IOVDD.n1171 17.0005
R7092 IOVDD.n1400 IOVDD.n1172 17.0005
R7093 IOVDD.n1400 IOVDD.n1173 17.0005
R7094 IOVDD.n1400 IOVDD.n1174 17.0005
R7095 IOVDD.n1400 IOVDD.n1175 17.0005
R7096 IOVDD.n1400 IOVDD.n1176 17.0005
R7097 IOVDD.n1400 IOVDD.n1177 17.0005
R7098 IOVDD.n1400 IOVDD.n1178 17.0005
R7099 IOVDD.n1400 IOVDD.n1209 17.0005
R7100 IOVDD.n1400 IOVDD.n1091 17.0005
R7101 IOVDD.n1400 IOVDD.n1210 17.0005
R7102 IOVDD.n1400 IOVDD.n1211 17.0005
R7103 IOVDD.n1400 IOVDD.n1212 17.0005
R7104 IOVDD.n1400 IOVDD.n1213 17.0005
R7105 IOVDD.n1400 IOVDD.n1214 17.0005
R7106 IOVDD.n1400 IOVDD.n1215 17.0005
R7107 IOVDD.n1400 IOVDD.n1216 17.0005
R7108 IOVDD.n1400 IOVDD.n1217 17.0005
R7109 IOVDD.n1400 IOVDD.n1218 17.0005
R7110 IOVDD.n1400 IOVDD.n1219 17.0005
R7111 IOVDD.n1400 IOVDD.n1220 17.0005
R7112 IOVDD.n1400 IOVDD.n1222 17.0005
R7113 IOVDD.n1400 IOVDD.n1223 17.0005
R7114 IOVDD.n1400 IOVDD.n1224 17.0005
R7115 IOVDD.n1400 IOVDD.n1225 17.0005
R7116 IOVDD.n1400 IOVDD.n1226 17.0005
R7117 IOVDD.n1400 IOVDD.n1227 17.0005
R7118 IOVDD.n1400 IOVDD.n1228 17.0005
R7119 IOVDD.n1400 IOVDD.n1229 17.0005
R7120 IOVDD.n1400 IOVDD.n1230 17.0005
R7121 IOVDD.n1400 IOVDD.n1231 17.0005
R7122 IOVDD.n1400 IOVDD.n1232 17.0005
R7123 IOVDD.n1400 IOVDD.n1233 17.0005
R7124 IOVDD.n1400 IOVDD.n1234 17.0005
R7125 IOVDD.n1400 IOVDD.n1235 17.0005
R7126 IOVDD.n1400 IOVDD.n1236 17.0005
R7127 IOVDD.n1400 IOVDD.n1237 17.0005
R7128 IOVDD.n1400 IOVDD.n1267 17.0005
R7129 IOVDD.n1533 IOVDD.t64 17.0005
R7130 IOVDD.n1533 IOVDD.t63 17.0005
R7131 IOVDD.n1539 IOVDD.t80 17.0005
R7132 IOVDD.n1539 IOVDD.t79 17.0005
R7133 IOVDD.n1545 IOVDD.t136 17.0005
R7134 IOVDD.n1545 IOVDD.t135 17.0005
R7135 IOVDD.n1542 IOVDD.n901 17.0005
R7136 IOVDD.n1512 IOVDD.n901 17.0005
R7137 IOVDD.n1567 IOVDD.n1557 17.0005
R7138 IOVDD.n1567 IOVDD.n1556 17.0005
R7139 IOVDD.n1567 IOVDD.n1555 17.0005
R7140 IOVDD.n1567 IOVDD.n1554 17.0005
R7141 IOVDD.n918 IOVDD.t143 17.0005
R7142 IOVDD.n914 IOVDD.t143 17.0005
R7143 IOVDD.n917 IOVDD.t143 17.0005
R7144 IOVDD.n915 IOVDD.t143 17.0005
R7145 IOVDD.n916 IOVDD.t143 17.0005
R7146 IOVDD.n919 IOVDD.t143 17.0005
R7147 IOVDD.n918 IOVDD.t142 17.0005
R7148 IOVDD.n914 IOVDD.t142 17.0005
R7149 IOVDD.n917 IOVDD.t142 17.0005
R7150 IOVDD.n915 IOVDD.t142 17.0005
R7151 IOVDD.n916 IOVDD.t142 17.0005
R7152 IOVDD.n919 IOVDD.t142 17.0005
R7153 IOVDD.n918 IOVDD.t71 17.0005
R7154 IOVDD.n914 IOVDD.t71 17.0005
R7155 IOVDD.n917 IOVDD.t71 17.0005
R7156 IOVDD.n915 IOVDD.t71 17.0005
R7157 IOVDD.n916 IOVDD.t71 17.0005
R7158 IOVDD.n919 IOVDD.t71 17.0005
R7159 IOVDD.t70 IOVDD.n918 17.0005
R7160 IOVDD.t70 IOVDD.n914 17.0005
R7161 IOVDD.t70 IOVDD.n917 17.0005
R7162 IOVDD.t70 IOVDD.n915 17.0005
R7163 IOVDD.t70 IOVDD.n916 17.0005
R7164 IOVDD.n919 IOVDD.t70 17.0005
R7165 IOVDD.n930 IOVDD.t45 17.0005
R7166 IOVDD.n926 IOVDD.t45 17.0005
R7167 IOVDD.n929 IOVDD.t45 17.0005
R7168 IOVDD.n927 IOVDD.t45 17.0005
R7169 IOVDD.n928 IOVDD.t45 17.0005
R7170 IOVDD.n931 IOVDD.t45 17.0005
R7171 IOVDD.n930 IOVDD.t44 17.0005
R7172 IOVDD.n926 IOVDD.t44 17.0005
R7173 IOVDD.n929 IOVDD.t44 17.0005
R7174 IOVDD.n927 IOVDD.t44 17.0005
R7175 IOVDD.n928 IOVDD.t44 17.0005
R7176 IOVDD.n931 IOVDD.t44 17.0005
R7177 IOVDD.n930 IOVDD.t110 17.0005
R7178 IOVDD.n926 IOVDD.t110 17.0005
R7179 IOVDD.n929 IOVDD.t110 17.0005
R7180 IOVDD.n927 IOVDD.t110 17.0005
R7181 IOVDD.n928 IOVDD.t110 17.0005
R7182 IOVDD.n931 IOVDD.t110 17.0005
R7183 IOVDD.t109 IOVDD.n930 17.0005
R7184 IOVDD.t109 IOVDD.n926 17.0005
R7185 IOVDD.t109 IOVDD.n929 17.0005
R7186 IOVDD.t109 IOVDD.n927 17.0005
R7187 IOVDD.t109 IOVDD.n928 17.0005
R7188 IOVDD.n931 IOVDD.t109 17.0005
R7189 IOVDD.n946 IOVDD.t48 17.0005
R7190 IOVDD.n942 IOVDD.t48 17.0005
R7191 IOVDD.n945 IOVDD.t48 17.0005
R7192 IOVDD.n943 IOVDD.t48 17.0005
R7193 IOVDD.n944 IOVDD.t48 17.0005
R7194 IOVDD.n947 IOVDD.t48 17.0005
R7195 IOVDD.n946 IOVDD.t47 17.0005
R7196 IOVDD.n942 IOVDD.t47 17.0005
R7197 IOVDD.n945 IOVDD.t47 17.0005
R7198 IOVDD.n943 IOVDD.t47 17.0005
R7199 IOVDD.n944 IOVDD.t47 17.0005
R7200 IOVDD.n947 IOVDD.t47 17.0005
R7201 IOVDD.n946 IOVDD.t113 17.0005
R7202 IOVDD.n942 IOVDD.t113 17.0005
R7203 IOVDD.n945 IOVDD.t113 17.0005
R7204 IOVDD.n943 IOVDD.t113 17.0005
R7205 IOVDD.n944 IOVDD.t113 17.0005
R7206 IOVDD.n947 IOVDD.t113 17.0005
R7207 IOVDD.t112 IOVDD.n946 17.0005
R7208 IOVDD.t112 IOVDD.n942 17.0005
R7209 IOVDD.t112 IOVDD.n945 17.0005
R7210 IOVDD.t112 IOVDD.n943 17.0005
R7211 IOVDD.t112 IOVDD.n944 17.0005
R7212 IOVDD.n947 IOVDD.t112 17.0005
R7213 IOVDD.n1553 IOVDD.n941 17.0005
R7214 IOVDD.n1553 IOVDD.n940 17.0005
R7215 IOVDD.n1553 IOVDD.n939 17.0005
R7216 IOVDD.n1553 IOVDD.n938 17.0005
R7217 IOVDD.n1553 IOVDD.n937 17.0005
R7218 IOVDD.n1553 IOVDD.n936 17.0005
R7219 IOVDD.n1553 IOVDD.n933 17.0005
R7220 IOVDD.n1553 IOVDD.n925 17.0005
R7221 IOVDD.n1553 IOVDD.n924 17.0005
R7222 IOVDD.n1553 IOVDD.n923 17.0005
R7223 IOVDD.n1553 IOVDD.n922 17.0005
R7224 IOVDD.n1553 IOVDD.n921 17.0005
R7225 IOVDD.n1553 IOVDD.n913 17.0005
R7226 IOVDD.n1553 IOVDD.n912 17.0005
R7227 IOVDD.n1553 IOVDD.n911 17.0005
R7228 IOVDD.n1553 IOVDD.n910 17.0005
R7229 IOVDD.n1553 IOVDD.n909 17.0005
R7230 IOVDD.n1553 IOVDD.n905 17.0005
R7231 IOVDD.t182 IOVDD.n851 17.0005
R7232 IOVDD.n852 IOVDD.t182 17.0005
R7233 IOVDD.n892 IOVDD.t105 17.0005
R7234 IOVDD.n890 IOVDD.t105 17.0005
R7235 IOVDD.n889 IOVDD.t105 17.0005
R7236 IOVDD.n893 IOVDD.t105 17.0005
R7237 IOVDD.t105 IOVDD.n888 17.0005
R7238 IOVDD.n891 IOVDD.t105 17.0005
R7239 IOVDD.n892 IOVDD.t104 17.0005
R7240 IOVDD.n890 IOVDD.t104 17.0005
R7241 IOVDD.n889 IOVDD.t104 17.0005
R7242 IOVDD.n893 IOVDD.t104 17.0005
R7243 IOVDD.t104 IOVDD.n888 17.0005
R7244 IOVDD.n891 IOVDD.t104 17.0005
R7245 IOVDD.n892 IOVDD.t166 17.0005
R7246 IOVDD.n890 IOVDD.t166 17.0005
R7247 IOVDD.n889 IOVDD.t166 17.0005
R7248 IOVDD.n893 IOVDD.t166 17.0005
R7249 IOVDD.t166 IOVDD.n888 17.0005
R7250 IOVDD.n891 IOVDD.t166 17.0005
R7251 IOVDD.t165 IOVDD.n892 17.0005
R7252 IOVDD.t165 IOVDD.n890 17.0005
R7253 IOVDD.t165 IOVDD.n889 17.0005
R7254 IOVDD.n893 IOVDD.t165 17.0005
R7255 IOVDD.t165 IOVDD.n888 17.0005
R7256 IOVDD.t165 IOVDD.n891 17.0005
R7257 IOVDD.n877 IOVDD.t102 17.0005
R7258 IOVDD.n875 IOVDD.t102 17.0005
R7259 IOVDD.n874 IOVDD.t102 17.0005
R7260 IOVDD.n873 IOVDD.t102 17.0005
R7261 IOVDD.n878 IOVDD.t102 17.0005
R7262 IOVDD.n876 IOVDD.t102 17.0005
R7263 IOVDD.n877 IOVDD.t101 17.0005
R7264 IOVDD.n875 IOVDD.t101 17.0005
R7265 IOVDD.n874 IOVDD.t101 17.0005
R7266 IOVDD.n873 IOVDD.t101 17.0005
R7267 IOVDD.n878 IOVDD.t101 17.0005
R7268 IOVDD.n876 IOVDD.t101 17.0005
R7269 IOVDD.n877 IOVDD.t163 17.0005
R7270 IOVDD.n875 IOVDD.t163 17.0005
R7271 IOVDD.n874 IOVDD.t163 17.0005
R7272 IOVDD.n873 IOVDD.t163 17.0005
R7273 IOVDD.n878 IOVDD.t163 17.0005
R7274 IOVDD.n876 IOVDD.t163 17.0005
R7275 IOVDD.t162 IOVDD.n877 17.0005
R7276 IOVDD.t162 IOVDD.n875 17.0005
R7277 IOVDD.t162 IOVDD.n874 17.0005
R7278 IOVDD.t162 IOVDD.n873 17.0005
R7279 IOVDD.n878 IOVDD.t162 17.0005
R7280 IOVDD.t162 IOVDD.n876 17.0005
R7281 IOVDD.n865 IOVDD.t58 17.0005
R7282 IOVDD.n863 IOVDD.t58 17.0005
R7283 IOVDD.n862 IOVDD.t58 17.0005
R7284 IOVDD.n861 IOVDD.t58 17.0005
R7285 IOVDD.n866 IOVDD.t58 17.0005
R7286 IOVDD.n864 IOVDD.t58 17.0005
R7287 IOVDD.n865 IOVDD.t128 17.0005
R7288 IOVDD.n863 IOVDD.t128 17.0005
R7289 IOVDD.n862 IOVDD.t128 17.0005
R7290 IOVDD.n861 IOVDD.t128 17.0005
R7291 IOVDD.n866 IOVDD.t128 17.0005
R7292 IOVDD.n864 IOVDD.t128 17.0005
R7293 IOVDD.n865 IOVDD.t127 17.0005
R7294 IOVDD.n863 IOVDD.t127 17.0005
R7295 IOVDD.n862 IOVDD.t127 17.0005
R7296 IOVDD.n861 IOVDD.t127 17.0005
R7297 IOVDD.n866 IOVDD.t127 17.0005
R7298 IOVDD.n864 IOVDD.t127 17.0005
R7299 IOVDD.t59 IOVDD.n865 17.0005
R7300 IOVDD.t59 IOVDD.n863 17.0005
R7301 IOVDD.t59 IOVDD.n862 17.0005
R7302 IOVDD.t59 IOVDD.n861 17.0005
R7303 IOVDD.n866 IOVDD.t59 17.0005
R7304 IOVDD.t59 IOVDD.n864 17.0005
R7305 IOVDD.n1567 IOVDD.n854 17.0005
R7306 IOVDD.n1567 IOVDD.n856 17.0005
R7307 IOVDD.n1567 IOVDD.n857 17.0005
R7308 IOVDD.n1567 IOVDD.n858 17.0005
R7309 IOVDD.n1567 IOVDD.n859 17.0005
R7310 IOVDD.n1567 IOVDD.n860 17.0005
R7311 IOVDD.n1567 IOVDD.n868 17.0005
R7312 IOVDD.n1567 IOVDD.n869 17.0005
R7313 IOVDD.n1567 IOVDD.n870 17.0005
R7314 IOVDD.n1567 IOVDD.n871 17.0005
R7315 IOVDD.n1567 IOVDD.n872 17.0005
R7316 IOVDD.n1567 IOVDD.n880 17.0005
R7317 IOVDD.n1567 IOVDD.n883 17.0005
R7318 IOVDD.n1567 IOVDD.n884 17.0005
R7319 IOVDD.n1567 IOVDD.n885 17.0005
R7320 IOVDD.n1567 IOVDD.n886 17.0005
R7321 IOVDD.n1567 IOVDD.n887 17.0005
R7322 IOVDD.n1567 IOVDD.n894 17.0005
R7323 IOVDD.n817 IOVDD.t77 17.0005
R7324 IOVDD.n817 IOVDD.t76 17.0005
R7325 IOVDD.n825 IOVDD.t178 17.0005
R7326 IOVDD.n825 IOVDD.t177 17.0005
R7327 IOVDD.n837 IOVDD.t154 17.0005
R7328 IOVDD.n837 IOVDD.t153 17.0005
R7329 IOVDD.n1576 IOVDD.n827 17.0005
R7330 IOVDD.n1576 IOVDD.n823 17.0005
R7331 IOVDD.n792 IOVDD.n365 17.0005
R7332 IOVDD.t157 IOVDD.n603 17.0005
R7333 IOVDD.t157 IOVDD.n575 17.0005
R7334 IOVDD.t157 IOVDD.n602 17.0005
R7335 IOVDD.t157 IOVDD.n576 17.0005
R7336 IOVDD.t157 IOVDD.n601 17.0005
R7337 IOVDD.t157 IOVDD.n577 17.0005
R7338 IOVDD.t157 IOVDD.n600 17.0005
R7339 IOVDD.t157 IOVDD.n578 17.0005
R7340 IOVDD.t157 IOVDD.n599 17.0005
R7341 IOVDD.t157 IOVDD.n579 17.0005
R7342 IOVDD.t157 IOVDD.n598 17.0005
R7343 IOVDD.t157 IOVDD.n580 17.0005
R7344 IOVDD.t157 IOVDD.n597 17.0005
R7345 IOVDD.t157 IOVDD.n584 17.0005
R7346 IOVDD.t157 IOVDD.n596 17.0005
R7347 IOVDD.t157 IOVDD.n585 17.0005
R7348 IOVDD.t157 IOVDD.n595 17.0005
R7349 IOVDD.t157 IOVDD.n586 17.0005
R7350 IOVDD.t157 IOVDD.n594 17.0005
R7351 IOVDD.t157 IOVDD.n587 17.0005
R7352 IOVDD.t157 IOVDD.n593 17.0005
R7353 IOVDD.t157 IOVDD.n588 17.0005
R7354 IOVDD.t157 IOVDD.n592 17.0005
R7355 IOVDD.t157 IOVDD.n589 17.0005
R7356 IOVDD.t157 IOVDD.n591 17.0005
R7357 IOVDD.t157 IOVDD.n590 17.0005
R7358 IOVDD.n604 IOVDD.t157 17.0005
R7359 IOVDD.n764 IOVDD.n540 17.0005
R7360 IOVDD.n764 IOVDD.n548 17.0005
R7361 IOVDD.n764 IOVDD.n549 17.0005
R7362 IOVDD.n764 IOVDD.n550 17.0005
R7363 IOVDD.n764 IOVDD.n551 17.0005
R7364 IOVDD.n764 IOVDD.n552 17.0005
R7365 IOVDD.n764 IOVDD.n553 17.0005
R7366 IOVDD.n764 IOVDD.n554 17.0005
R7367 IOVDD.n764 IOVDD.n555 17.0005
R7368 IOVDD.n764 IOVDD.n556 17.0005
R7369 IOVDD.n764 IOVDD.n557 17.0005
R7370 IOVDD.n764 IOVDD.n558 17.0005
R7371 IOVDD.n764 IOVDD.n559 17.0005
R7372 IOVDD.n764 IOVDD.n560 17.0005
R7373 IOVDD.n764 IOVDD.n561 17.0005
R7374 IOVDD.n764 IOVDD.n562 17.0005
R7375 IOVDD.n764 IOVDD.n563 17.0005
R7376 IOVDD.n764 IOVDD.n564 17.0005
R7377 IOVDD.n764 IOVDD.n565 17.0005
R7378 IOVDD.n764 IOVDD.n566 17.0005
R7379 IOVDD.n764 IOVDD.n567 17.0005
R7380 IOVDD.n764 IOVDD.n568 17.0005
R7381 IOVDD.n764 IOVDD.n569 17.0005
R7382 IOVDD.n764 IOVDD.n570 17.0005
R7383 IOVDD.n764 IOVDD.n571 17.0005
R7384 IOVDD.n764 IOVDD.n572 17.0005
R7385 IOVDD.n764 IOVDD.n573 17.0005
R7386 IOVDD.n764 IOVDD.n574 17.0005
R7387 IOVDD.n764 IOVDD.n605 17.0005
R7388 IOVDD.n744 IOVDD.t34 17.0005
R7389 IOVDD.n742 IOVDD.t34 17.0005
R7390 IOVDD.n741 IOVDD.t34 17.0005
R7391 IOVDD.n740 IOVDD.t34 17.0005
R7392 IOVDD.n739 IOVDD.t34 17.0005
R7393 IOVDD.n738 IOVDD.t34 17.0005
R7394 IOVDD.n737 IOVDD.t34 17.0005
R7395 IOVDD.n736 IOVDD.t34 17.0005
R7396 IOVDD.n735 IOVDD.t34 17.0005
R7397 IOVDD.n734 IOVDD.t34 17.0005
R7398 IOVDD.n733 IOVDD.t34 17.0005
R7399 IOVDD.n732 IOVDD.t34 17.0005
R7400 IOVDD.n731 IOVDD.t34 17.0005
R7401 IOVDD.n730 IOVDD.t34 17.0005
R7402 IOVDD.n729 IOVDD.t34 17.0005
R7403 IOVDD.n728 IOVDD.t34 17.0005
R7404 IOVDD.n727 IOVDD.t34 17.0005
R7405 IOVDD.n726 IOVDD.t34 17.0005
R7406 IOVDD.n725 IOVDD.t34 17.0005
R7407 IOVDD.n724 IOVDD.t34 17.0005
R7408 IOVDD.n723 IOVDD.t34 17.0005
R7409 IOVDD.n722 IOVDD.t34 17.0005
R7410 IOVDD.n721 IOVDD.t34 17.0005
R7411 IOVDD.n720 IOVDD.t34 17.0005
R7412 IOVDD.n719 IOVDD.t34 17.0005
R7413 IOVDD.n718 IOVDD.t34 17.0005
R7414 IOVDD.n717 IOVDD.t34 17.0005
R7415 IOVDD.n745 IOVDD.t34 17.0005
R7416 IOVDD.n743 IOVDD.t34 17.0005
R7417 IOVDD.n744 IOVDD.t86 17.0005
R7418 IOVDD.n742 IOVDD.t86 17.0005
R7419 IOVDD.n741 IOVDD.t86 17.0005
R7420 IOVDD.n740 IOVDD.t86 17.0005
R7421 IOVDD.n739 IOVDD.t86 17.0005
R7422 IOVDD.n738 IOVDD.t86 17.0005
R7423 IOVDD.n737 IOVDD.t86 17.0005
R7424 IOVDD.n736 IOVDD.t86 17.0005
R7425 IOVDD.n735 IOVDD.t86 17.0005
R7426 IOVDD.n734 IOVDD.t86 17.0005
R7427 IOVDD.n733 IOVDD.t86 17.0005
R7428 IOVDD.n732 IOVDD.t86 17.0005
R7429 IOVDD.n731 IOVDD.t86 17.0005
R7430 IOVDD.n730 IOVDD.t86 17.0005
R7431 IOVDD.n729 IOVDD.t86 17.0005
R7432 IOVDD.n728 IOVDD.t86 17.0005
R7433 IOVDD.n727 IOVDD.t86 17.0005
R7434 IOVDD.n726 IOVDD.t86 17.0005
R7435 IOVDD.n725 IOVDD.t86 17.0005
R7436 IOVDD.n724 IOVDD.t86 17.0005
R7437 IOVDD.n723 IOVDD.t86 17.0005
R7438 IOVDD.n722 IOVDD.t86 17.0005
R7439 IOVDD.n721 IOVDD.t86 17.0005
R7440 IOVDD.n720 IOVDD.t86 17.0005
R7441 IOVDD.n719 IOVDD.t86 17.0005
R7442 IOVDD.n718 IOVDD.t86 17.0005
R7443 IOVDD.n717 IOVDD.t86 17.0005
R7444 IOVDD.n745 IOVDD.t86 17.0005
R7445 IOVDD.n743 IOVDD.t86 17.0005
R7446 IOVDD.t35 IOVDD.n744 17.0005
R7447 IOVDD.t35 IOVDD.n742 17.0005
R7448 IOVDD.t35 IOVDD.n741 17.0005
R7449 IOVDD.t35 IOVDD.n740 17.0005
R7450 IOVDD.t35 IOVDD.n739 17.0005
R7451 IOVDD.t35 IOVDD.n738 17.0005
R7452 IOVDD.t35 IOVDD.n737 17.0005
R7453 IOVDD.t35 IOVDD.n736 17.0005
R7454 IOVDD.t35 IOVDD.n735 17.0005
R7455 IOVDD.t35 IOVDD.n734 17.0005
R7456 IOVDD.t35 IOVDD.n733 17.0005
R7457 IOVDD.t35 IOVDD.n732 17.0005
R7458 IOVDD.t35 IOVDD.n731 17.0005
R7459 IOVDD.t35 IOVDD.n730 17.0005
R7460 IOVDD.t35 IOVDD.n729 17.0005
R7461 IOVDD.t35 IOVDD.n728 17.0005
R7462 IOVDD.t35 IOVDD.n727 17.0005
R7463 IOVDD.t35 IOVDD.n726 17.0005
R7464 IOVDD.t35 IOVDD.n725 17.0005
R7465 IOVDD.t35 IOVDD.n724 17.0005
R7466 IOVDD.t35 IOVDD.n723 17.0005
R7467 IOVDD.t35 IOVDD.n722 17.0005
R7468 IOVDD.t35 IOVDD.n721 17.0005
R7469 IOVDD.t35 IOVDD.n720 17.0005
R7470 IOVDD.t35 IOVDD.n719 17.0005
R7471 IOVDD.t35 IOVDD.n718 17.0005
R7472 IOVDD.t35 IOVDD.n717 17.0005
R7473 IOVDD.n745 IOVDD.t35 17.0005
R7474 IOVDD.t35 IOVDD.n743 17.0005
R7475 IOVDD.n671 IOVDD.t159 17.0005
R7476 IOVDD.n669 IOVDD.t159 17.0005
R7477 IOVDD.n668 IOVDD.t159 17.0005
R7478 IOVDD.n667 IOVDD.t159 17.0005
R7479 IOVDD.n666 IOVDD.t159 17.0005
R7480 IOVDD.n665 IOVDD.t159 17.0005
R7481 IOVDD.n664 IOVDD.t159 17.0005
R7482 IOVDD.n663 IOVDD.t159 17.0005
R7483 IOVDD.n662 IOVDD.t159 17.0005
R7484 IOVDD.n661 IOVDD.t159 17.0005
R7485 IOVDD.n660 IOVDD.t159 17.0005
R7486 IOVDD.n659 IOVDD.t159 17.0005
R7487 IOVDD.n658 IOVDD.t159 17.0005
R7488 IOVDD.n657 IOVDD.t159 17.0005
R7489 IOVDD.n656 IOVDD.t159 17.0005
R7490 IOVDD.n655 IOVDD.t159 17.0005
R7491 IOVDD.n654 IOVDD.t159 17.0005
R7492 IOVDD.n653 IOVDD.t159 17.0005
R7493 IOVDD.n652 IOVDD.t159 17.0005
R7494 IOVDD.n651 IOVDD.t159 17.0005
R7495 IOVDD.n650 IOVDD.t159 17.0005
R7496 IOVDD.n649 IOVDD.t159 17.0005
R7497 IOVDD.n648 IOVDD.t159 17.0005
R7498 IOVDD.n647 IOVDD.t159 17.0005
R7499 IOVDD.n646 IOVDD.t159 17.0005
R7500 IOVDD.n645 IOVDD.t159 17.0005
R7501 IOVDD.n644 IOVDD.t159 17.0005
R7502 IOVDD.n672 IOVDD.t159 17.0005
R7503 IOVDD.n670 IOVDD.t159 17.0005
R7504 IOVDD.n671 IOVDD.t67 17.0005
R7505 IOVDD.n669 IOVDD.t67 17.0005
R7506 IOVDD.n668 IOVDD.t67 17.0005
R7507 IOVDD.n667 IOVDD.t67 17.0005
R7508 IOVDD.n666 IOVDD.t67 17.0005
R7509 IOVDD.n665 IOVDD.t67 17.0005
R7510 IOVDD.n664 IOVDD.t67 17.0005
R7511 IOVDD.n663 IOVDD.t67 17.0005
R7512 IOVDD.n662 IOVDD.t67 17.0005
R7513 IOVDD.n661 IOVDD.t67 17.0005
R7514 IOVDD.n660 IOVDD.t67 17.0005
R7515 IOVDD.n659 IOVDD.t67 17.0005
R7516 IOVDD.n658 IOVDD.t67 17.0005
R7517 IOVDD.n657 IOVDD.t67 17.0005
R7518 IOVDD.n656 IOVDD.t67 17.0005
R7519 IOVDD.n655 IOVDD.t67 17.0005
R7520 IOVDD.n654 IOVDD.t67 17.0005
R7521 IOVDD.n653 IOVDD.t67 17.0005
R7522 IOVDD.n652 IOVDD.t67 17.0005
R7523 IOVDD.n651 IOVDD.t67 17.0005
R7524 IOVDD.n650 IOVDD.t67 17.0005
R7525 IOVDD.n649 IOVDD.t67 17.0005
R7526 IOVDD.n648 IOVDD.t67 17.0005
R7527 IOVDD.n647 IOVDD.t67 17.0005
R7528 IOVDD.n646 IOVDD.t67 17.0005
R7529 IOVDD.n645 IOVDD.t67 17.0005
R7530 IOVDD.n644 IOVDD.t67 17.0005
R7531 IOVDD.n672 IOVDD.t67 17.0005
R7532 IOVDD.n670 IOVDD.t67 17.0005
R7533 IOVDD.t160 IOVDD.n671 17.0005
R7534 IOVDD.t160 IOVDD.n669 17.0005
R7535 IOVDD.t160 IOVDD.n668 17.0005
R7536 IOVDD.t160 IOVDD.n667 17.0005
R7537 IOVDD.t160 IOVDD.n666 17.0005
R7538 IOVDD.t160 IOVDD.n665 17.0005
R7539 IOVDD.t160 IOVDD.n664 17.0005
R7540 IOVDD.t160 IOVDD.n663 17.0005
R7541 IOVDD.t160 IOVDD.n662 17.0005
R7542 IOVDD.t160 IOVDD.n661 17.0005
R7543 IOVDD.t160 IOVDD.n660 17.0005
R7544 IOVDD.t160 IOVDD.n659 17.0005
R7545 IOVDD.t160 IOVDD.n658 17.0005
R7546 IOVDD.t160 IOVDD.n657 17.0005
R7547 IOVDD.t160 IOVDD.n656 17.0005
R7548 IOVDD.t160 IOVDD.n655 17.0005
R7549 IOVDD.t160 IOVDD.n654 17.0005
R7550 IOVDD.t160 IOVDD.n653 17.0005
R7551 IOVDD.t160 IOVDD.n652 17.0005
R7552 IOVDD.t160 IOVDD.n651 17.0005
R7553 IOVDD.t160 IOVDD.n650 17.0005
R7554 IOVDD.t160 IOVDD.n649 17.0005
R7555 IOVDD.t160 IOVDD.n648 17.0005
R7556 IOVDD.t160 IOVDD.n647 17.0005
R7557 IOVDD.t160 IOVDD.n646 17.0005
R7558 IOVDD.t160 IOVDD.n645 17.0005
R7559 IOVDD.t160 IOVDD.n644 17.0005
R7560 IOVDD.n672 IOVDD.t160 17.0005
R7561 IOVDD.t160 IOVDD.n670 17.0005
R7562 IOVDD.n764 IOVDD.n616 17.0005
R7563 IOVDD.n764 IOVDD.n617 17.0005
R7564 IOVDD.n764 IOVDD.n618 17.0005
R7565 IOVDD.n764 IOVDD.n619 17.0005
R7566 IOVDD.n764 IOVDD.n620 17.0005
R7567 IOVDD.n764 IOVDD.n621 17.0005
R7568 IOVDD.n764 IOVDD.n622 17.0005
R7569 IOVDD.n764 IOVDD.n623 17.0005
R7570 IOVDD.n764 IOVDD.n624 17.0005
R7571 IOVDD.n764 IOVDD.n625 17.0005
R7572 IOVDD.n764 IOVDD.n626 17.0005
R7573 IOVDD.n764 IOVDD.n627 17.0005
R7574 IOVDD.n764 IOVDD.n628 17.0005
R7575 IOVDD.n764 IOVDD.n629 17.0005
R7576 IOVDD.n764 IOVDD.n630 17.0005
R7577 IOVDD.n764 IOVDD.n631 17.0005
R7578 IOVDD.n764 IOVDD.n632 17.0005
R7579 IOVDD.n764 IOVDD.n633 17.0005
R7580 IOVDD.n764 IOVDD.n634 17.0005
R7581 IOVDD.n764 IOVDD.n635 17.0005
R7582 IOVDD.n764 IOVDD.n636 17.0005
R7583 IOVDD.n764 IOVDD.n637 17.0005
R7584 IOVDD.n764 IOVDD.n638 17.0005
R7585 IOVDD.n764 IOVDD.n639 17.0005
R7586 IOVDD.n764 IOVDD.n640 17.0005
R7587 IOVDD.n764 IOVDD.n641 17.0005
R7588 IOVDD.n764 IOVDD.n642 17.0005
R7589 IOVDD.n764 IOVDD.n643 17.0005
R7590 IOVDD.n764 IOVDD.n689 17.0005
R7591 IOVDD.n764 IOVDD.n690 17.0005
R7592 IOVDD.n764 IOVDD.n691 17.0005
R7593 IOVDD.n764 IOVDD.n692 17.0005
R7594 IOVDD.n764 IOVDD.n693 17.0005
R7595 IOVDD.n764 IOVDD.n694 17.0005
R7596 IOVDD.n764 IOVDD.n695 17.0005
R7597 IOVDD.n764 IOVDD.n696 17.0005
R7598 IOVDD.n764 IOVDD.n697 17.0005
R7599 IOVDD.n764 IOVDD.n698 17.0005
R7600 IOVDD.n764 IOVDD.n699 17.0005
R7601 IOVDD.n764 IOVDD.n700 17.0005
R7602 IOVDD.n764 IOVDD.n701 17.0005
R7603 IOVDD.n764 IOVDD.n702 17.0005
R7604 IOVDD.n764 IOVDD.n703 17.0005
R7605 IOVDD.n764 IOVDD.n704 17.0005
R7606 IOVDD.n764 IOVDD.n705 17.0005
R7607 IOVDD.n764 IOVDD.n706 17.0005
R7608 IOVDD.n764 IOVDD.n707 17.0005
R7609 IOVDD.n764 IOVDD.n708 17.0005
R7610 IOVDD.n764 IOVDD.n709 17.0005
R7611 IOVDD.n764 IOVDD.n710 17.0005
R7612 IOVDD.n764 IOVDD.n711 17.0005
R7613 IOVDD.n764 IOVDD.n712 17.0005
R7614 IOVDD.n764 IOVDD.n713 17.0005
R7615 IOVDD.n764 IOVDD.n714 17.0005
R7616 IOVDD.n764 IOVDD.n715 17.0005
R7617 IOVDD.n764 IOVDD.n716 17.0005
R7618 IOVDD.n429 IOVDD.t91 17.0005
R7619 IOVDD.n402 IOVDD.t91 17.0005
R7620 IOVDD.n428 IOVDD.t91 17.0005
R7621 IOVDD.n403 IOVDD.t91 17.0005
R7622 IOVDD.n427 IOVDD.t91 17.0005
R7623 IOVDD.n404 IOVDD.t91 17.0005
R7624 IOVDD.n426 IOVDD.t91 17.0005
R7625 IOVDD.n405 IOVDD.t91 17.0005
R7626 IOVDD.n425 IOVDD.t91 17.0005
R7627 IOVDD.n406 IOVDD.t91 17.0005
R7628 IOVDD.n424 IOVDD.t91 17.0005
R7629 IOVDD.n407 IOVDD.t91 17.0005
R7630 IOVDD.n423 IOVDD.t91 17.0005
R7631 IOVDD.n408 IOVDD.t91 17.0005
R7632 IOVDD.n422 IOVDD.t91 17.0005
R7633 IOVDD.n409 IOVDD.t91 17.0005
R7634 IOVDD.n421 IOVDD.t91 17.0005
R7635 IOVDD.n410 IOVDD.t91 17.0005
R7636 IOVDD.n420 IOVDD.t91 17.0005
R7637 IOVDD.n411 IOVDD.t91 17.0005
R7638 IOVDD.n419 IOVDD.t91 17.0005
R7639 IOVDD.n412 IOVDD.t91 17.0005
R7640 IOVDD.n418 IOVDD.t91 17.0005
R7641 IOVDD.n413 IOVDD.t91 17.0005
R7642 IOVDD.n417 IOVDD.t91 17.0005
R7643 IOVDD.n414 IOVDD.t91 17.0005
R7644 IOVDD.n416 IOVDD.t91 17.0005
R7645 IOVDD.n415 IOVDD.t91 17.0005
R7646 IOVDD.n430 IOVDD.t91 17.0005
R7647 IOVDD.n429 IOVDD.t90 17.0005
R7648 IOVDD.n402 IOVDD.t90 17.0005
R7649 IOVDD.n428 IOVDD.t90 17.0005
R7650 IOVDD.n403 IOVDD.t90 17.0005
R7651 IOVDD.n427 IOVDD.t90 17.0005
R7652 IOVDD.n404 IOVDD.t90 17.0005
R7653 IOVDD.n426 IOVDD.t90 17.0005
R7654 IOVDD.n405 IOVDD.t90 17.0005
R7655 IOVDD.n425 IOVDD.t90 17.0005
R7656 IOVDD.n406 IOVDD.t90 17.0005
R7657 IOVDD.n424 IOVDD.t90 17.0005
R7658 IOVDD.n407 IOVDD.t90 17.0005
R7659 IOVDD.n423 IOVDD.t90 17.0005
R7660 IOVDD.n408 IOVDD.t90 17.0005
R7661 IOVDD.n422 IOVDD.t90 17.0005
R7662 IOVDD.n409 IOVDD.t90 17.0005
R7663 IOVDD.n421 IOVDD.t90 17.0005
R7664 IOVDD.n410 IOVDD.t90 17.0005
R7665 IOVDD.n420 IOVDD.t90 17.0005
R7666 IOVDD.n411 IOVDD.t90 17.0005
R7667 IOVDD.n419 IOVDD.t90 17.0005
R7668 IOVDD.n412 IOVDD.t90 17.0005
R7669 IOVDD.n418 IOVDD.t90 17.0005
R7670 IOVDD.n413 IOVDD.t90 17.0005
R7671 IOVDD.n417 IOVDD.t90 17.0005
R7672 IOVDD.n414 IOVDD.t90 17.0005
R7673 IOVDD.n416 IOVDD.t90 17.0005
R7674 IOVDD.n415 IOVDD.t90 17.0005
R7675 IOVDD.n430 IOVDD.t90 17.0005
R7676 IOVDD.n429 IOVDD.t52 17.0005
R7677 IOVDD.n402 IOVDD.t52 17.0005
R7678 IOVDD.n428 IOVDD.t52 17.0005
R7679 IOVDD.n403 IOVDD.t52 17.0005
R7680 IOVDD.n427 IOVDD.t52 17.0005
R7681 IOVDD.n404 IOVDD.t52 17.0005
R7682 IOVDD.n426 IOVDD.t52 17.0005
R7683 IOVDD.n405 IOVDD.t52 17.0005
R7684 IOVDD.n425 IOVDD.t52 17.0005
R7685 IOVDD.n406 IOVDD.t52 17.0005
R7686 IOVDD.n424 IOVDD.t52 17.0005
R7687 IOVDD.n407 IOVDD.t52 17.0005
R7688 IOVDD.n423 IOVDD.t52 17.0005
R7689 IOVDD.n408 IOVDD.t52 17.0005
R7690 IOVDD.n422 IOVDD.t52 17.0005
R7691 IOVDD.n409 IOVDD.t52 17.0005
R7692 IOVDD.n421 IOVDD.t52 17.0005
R7693 IOVDD.n410 IOVDD.t52 17.0005
R7694 IOVDD.n420 IOVDD.t52 17.0005
R7695 IOVDD.n411 IOVDD.t52 17.0005
R7696 IOVDD.n419 IOVDD.t52 17.0005
R7697 IOVDD.n412 IOVDD.t52 17.0005
R7698 IOVDD.n418 IOVDD.t52 17.0005
R7699 IOVDD.n413 IOVDD.t52 17.0005
R7700 IOVDD.n417 IOVDD.t52 17.0005
R7701 IOVDD.n414 IOVDD.t52 17.0005
R7702 IOVDD.n416 IOVDD.t52 17.0005
R7703 IOVDD.n415 IOVDD.t52 17.0005
R7704 IOVDD.n430 IOVDD.t52 17.0005
R7705 IOVDD.t51 IOVDD.n429 17.0005
R7706 IOVDD.t51 IOVDD.n402 17.0005
R7707 IOVDD.t51 IOVDD.n428 17.0005
R7708 IOVDD.t51 IOVDD.n403 17.0005
R7709 IOVDD.t51 IOVDD.n427 17.0005
R7710 IOVDD.t51 IOVDD.n404 17.0005
R7711 IOVDD.t51 IOVDD.n426 17.0005
R7712 IOVDD.t51 IOVDD.n405 17.0005
R7713 IOVDD.t51 IOVDD.n425 17.0005
R7714 IOVDD.t51 IOVDD.n406 17.0005
R7715 IOVDD.t51 IOVDD.n424 17.0005
R7716 IOVDD.t51 IOVDD.n407 17.0005
R7717 IOVDD.t51 IOVDD.n423 17.0005
R7718 IOVDD.t51 IOVDD.n408 17.0005
R7719 IOVDD.t51 IOVDD.n422 17.0005
R7720 IOVDD.t51 IOVDD.n409 17.0005
R7721 IOVDD.t51 IOVDD.n421 17.0005
R7722 IOVDD.t51 IOVDD.n410 17.0005
R7723 IOVDD.t51 IOVDD.n420 17.0005
R7724 IOVDD.t51 IOVDD.n411 17.0005
R7725 IOVDD.t51 IOVDD.n419 17.0005
R7726 IOVDD.t51 IOVDD.n412 17.0005
R7727 IOVDD.t51 IOVDD.n418 17.0005
R7728 IOVDD.t51 IOVDD.n413 17.0005
R7729 IOVDD.t51 IOVDD.n417 17.0005
R7730 IOVDD.t51 IOVDD.n414 17.0005
R7731 IOVDD.t51 IOVDD.n416 17.0005
R7732 IOVDD.t51 IOVDD.n415 17.0005
R7733 IOVDD.n430 IOVDD.t51 17.0005
R7734 IOVDD.n493 IOVDD.t118 17.0005
R7735 IOVDD.n466 IOVDD.t118 17.0005
R7736 IOVDD.n492 IOVDD.t118 17.0005
R7737 IOVDD.n467 IOVDD.t118 17.0005
R7738 IOVDD.n491 IOVDD.t118 17.0005
R7739 IOVDD.n468 IOVDD.t118 17.0005
R7740 IOVDD.n490 IOVDD.t118 17.0005
R7741 IOVDD.n469 IOVDD.t118 17.0005
R7742 IOVDD.n489 IOVDD.t118 17.0005
R7743 IOVDD.n470 IOVDD.t118 17.0005
R7744 IOVDD.n488 IOVDD.t118 17.0005
R7745 IOVDD.n471 IOVDD.t118 17.0005
R7746 IOVDD.n487 IOVDD.t118 17.0005
R7747 IOVDD.n472 IOVDD.t118 17.0005
R7748 IOVDD.n486 IOVDD.t118 17.0005
R7749 IOVDD.n473 IOVDD.t118 17.0005
R7750 IOVDD.n485 IOVDD.t118 17.0005
R7751 IOVDD.n474 IOVDD.t118 17.0005
R7752 IOVDD.n484 IOVDD.t118 17.0005
R7753 IOVDD.n475 IOVDD.t118 17.0005
R7754 IOVDD.n483 IOVDD.t118 17.0005
R7755 IOVDD.n476 IOVDD.t118 17.0005
R7756 IOVDD.n482 IOVDD.t118 17.0005
R7757 IOVDD.n477 IOVDD.t118 17.0005
R7758 IOVDD.n481 IOVDD.t118 17.0005
R7759 IOVDD.n478 IOVDD.t118 17.0005
R7760 IOVDD.n480 IOVDD.t118 17.0005
R7761 IOVDD.n479 IOVDD.t118 17.0005
R7762 IOVDD.n494 IOVDD.t118 17.0005
R7763 IOVDD.n493 IOVDD.t117 17.0005
R7764 IOVDD.n466 IOVDD.t117 17.0005
R7765 IOVDD.n492 IOVDD.t117 17.0005
R7766 IOVDD.n467 IOVDD.t117 17.0005
R7767 IOVDD.n491 IOVDD.t117 17.0005
R7768 IOVDD.n468 IOVDD.t117 17.0005
R7769 IOVDD.n490 IOVDD.t117 17.0005
R7770 IOVDD.n469 IOVDD.t117 17.0005
R7771 IOVDD.n489 IOVDD.t117 17.0005
R7772 IOVDD.n470 IOVDD.t117 17.0005
R7773 IOVDD.n488 IOVDD.t117 17.0005
R7774 IOVDD.n471 IOVDD.t117 17.0005
R7775 IOVDD.n487 IOVDD.t117 17.0005
R7776 IOVDD.n472 IOVDD.t117 17.0005
R7777 IOVDD.n486 IOVDD.t117 17.0005
R7778 IOVDD.n473 IOVDD.t117 17.0005
R7779 IOVDD.n485 IOVDD.t117 17.0005
R7780 IOVDD.n474 IOVDD.t117 17.0005
R7781 IOVDD.n484 IOVDD.t117 17.0005
R7782 IOVDD.n475 IOVDD.t117 17.0005
R7783 IOVDD.n483 IOVDD.t117 17.0005
R7784 IOVDD.n476 IOVDD.t117 17.0005
R7785 IOVDD.n482 IOVDD.t117 17.0005
R7786 IOVDD.n477 IOVDD.t117 17.0005
R7787 IOVDD.n481 IOVDD.t117 17.0005
R7788 IOVDD.n478 IOVDD.t117 17.0005
R7789 IOVDD.n480 IOVDD.t117 17.0005
R7790 IOVDD.n479 IOVDD.t117 17.0005
R7791 IOVDD.n494 IOVDD.t117 17.0005
R7792 IOVDD.n493 IOVDD.t74 17.0005
R7793 IOVDD.n466 IOVDD.t74 17.0005
R7794 IOVDD.n492 IOVDD.t74 17.0005
R7795 IOVDD.n467 IOVDD.t74 17.0005
R7796 IOVDD.n491 IOVDD.t74 17.0005
R7797 IOVDD.n468 IOVDD.t74 17.0005
R7798 IOVDD.n490 IOVDD.t74 17.0005
R7799 IOVDD.n469 IOVDD.t74 17.0005
R7800 IOVDD.n489 IOVDD.t74 17.0005
R7801 IOVDD.n470 IOVDD.t74 17.0005
R7802 IOVDD.n488 IOVDD.t74 17.0005
R7803 IOVDD.n471 IOVDD.t74 17.0005
R7804 IOVDD.n487 IOVDD.t74 17.0005
R7805 IOVDD.n472 IOVDD.t74 17.0005
R7806 IOVDD.n486 IOVDD.t74 17.0005
R7807 IOVDD.n473 IOVDD.t74 17.0005
R7808 IOVDD.n485 IOVDD.t74 17.0005
R7809 IOVDD.n474 IOVDD.t74 17.0005
R7810 IOVDD.n484 IOVDD.t74 17.0005
R7811 IOVDD.n475 IOVDD.t74 17.0005
R7812 IOVDD.n483 IOVDD.t74 17.0005
R7813 IOVDD.n476 IOVDD.t74 17.0005
R7814 IOVDD.n482 IOVDD.t74 17.0005
R7815 IOVDD.n477 IOVDD.t74 17.0005
R7816 IOVDD.n481 IOVDD.t74 17.0005
R7817 IOVDD.n478 IOVDD.t74 17.0005
R7818 IOVDD.n480 IOVDD.t74 17.0005
R7819 IOVDD.n479 IOVDD.t74 17.0005
R7820 IOVDD.n494 IOVDD.t74 17.0005
R7821 IOVDD.t73 IOVDD.n493 17.0005
R7822 IOVDD.t73 IOVDD.n466 17.0005
R7823 IOVDD.t73 IOVDD.n492 17.0005
R7824 IOVDD.t73 IOVDD.n467 17.0005
R7825 IOVDD.t73 IOVDD.n491 17.0005
R7826 IOVDD.t73 IOVDD.n468 17.0005
R7827 IOVDD.t73 IOVDD.n490 17.0005
R7828 IOVDD.t73 IOVDD.n469 17.0005
R7829 IOVDD.t73 IOVDD.n489 17.0005
R7830 IOVDD.t73 IOVDD.n470 17.0005
R7831 IOVDD.t73 IOVDD.n488 17.0005
R7832 IOVDD.t73 IOVDD.n471 17.0005
R7833 IOVDD.t73 IOVDD.n487 17.0005
R7834 IOVDD.t73 IOVDD.n472 17.0005
R7835 IOVDD.t73 IOVDD.n486 17.0005
R7836 IOVDD.t73 IOVDD.n473 17.0005
R7837 IOVDD.t73 IOVDD.n485 17.0005
R7838 IOVDD.t73 IOVDD.n474 17.0005
R7839 IOVDD.t73 IOVDD.n484 17.0005
R7840 IOVDD.t73 IOVDD.n475 17.0005
R7841 IOVDD.t73 IOVDD.n483 17.0005
R7842 IOVDD.t73 IOVDD.n476 17.0005
R7843 IOVDD.t73 IOVDD.n482 17.0005
R7844 IOVDD.t73 IOVDD.n477 17.0005
R7845 IOVDD.t73 IOVDD.n481 17.0005
R7846 IOVDD.t73 IOVDD.n478 17.0005
R7847 IOVDD.t73 IOVDD.n480 17.0005
R7848 IOVDD.t73 IOVDD.n479 17.0005
R7849 IOVDD.n494 IOVDD.t73 17.0005
R7850 IOVDD.n792 IOVDD.n465 17.0005
R7851 IOVDD.n792 IOVDD.n464 17.0005
R7852 IOVDD.n792 IOVDD.n463 17.0005
R7853 IOVDD.n792 IOVDD.n462 17.0005
R7854 IOVDD.n792 IOVDD.n461 17.0005
R7855 IOVDD.n792 IOVDD.n460 17.0005
R7856 IOVDD.n792 IOVDD.n459 17.0005
R7857 IOVDD.n792 IOVDD.n458 17.0005
R7858 IOVDD.n792 IOVDD.n457 17.0005
R7859 IOVDD.n792 IOVDD.n456 17.0005
R7860 IOVDD.n792 IOVDD.n455 17.0005
R7861 IOVDD.n792 IOVDD.n454 17.0005
R7862 IOVDD.n792 IOVDD.n453 17.0005
R7863 IOVDD.n792 IOVDD.n452 17.0005
R7864 IOVDD.n792 IOVDD.n451 17.0005
R7865 IOVDD.n792 IOVDD.n450 17.0005
R7866 IOVDD.n792 IOVDD.n449 17.0005
R7867 IOVDD.n792 IOVDD.n448 17.0005
R7868 IOVDD.n792 IOVDD.n447 17.0005
R7869 IOVDD.n792 IOVDD.n446 17.0005
R7870 IOVDD.n792 IOVDD.n445 17.0005
R7871 IOVDD.n792 IOVDD.n444 17.0005
R7872 IOVDD.n792 IOVDD.n443 17.0005
R7873 IOVDD.n792 IOVDD.n442 17.0005
R7874 IOVDD.n792 IOVDD.n441 17.0005
R7875 IOVDD.n792 IOVDD.n440 17.0005
R7876 IOVDD.n792 IOVDD.n439 17.0005
R7877 IOVDD.n792 IOVDD.n438 17.0005
R7878 IOVDD.n792 IOVDD.n401 17.0005
R7879 IOVDD.n792 IOVDD.n400 17.0005
R7880 IOVDD.n792 IOVDD.n399 17.0005
R7881 IOVDD.n792 IOVDD.n398 17.0005
R7882 IOVDD.n792 IOVDD.n397 17.0005
R7883 IOVDD.n792 IOVDD.n396 17.0005
R7884 IOVDD.n792 IOVDD.n395 17.0005
R7885 IOVDD.n792 IOVDD.n394 17.0005
R7886 IOVDD.n792 IOVDD.n393 17.0005
R7887 IOVDD.n792 IOVDD.n392 17.0005
R7888 IOVDD.n792 IOVDD.n391 17.0005
R7889 IOVDD.n792 IOVDD.n390 17.0005
R7890 IOVDD.n792 IOVDD.n389 17.0005
R7891 IOVDD.n792 IOVDD.n388 17.0005
R7892 IOVDD.n792 IOVDD.n387 17.0005
R7893 IOVDD.n792 IOVDD.n386 17.0005
R7894 IOVDD.n792 IOVDD.n385 17.0005
R7895 IOVDD.n792 IOVDD.n384 17.0005
R7896 IOVDD.n792 IOVDD.n383 17.0005
R7897 IOVDD.n792 IOVDD.n382 17.0005
R7898 IOVDD.n792 IOVDD.n381 17.0005
R7899 IOVDD.n792 IOVDD.n380 17.0005
R7900 IOVDD.n792 IOVDD.n379 17.0005
R7901 IOVDD.n792 IOVDD.n378 17.0005
R7902 IOVDD.n792 IOVDD.n377 17.0005
R7903 IOVDD.n792 IOVDD.n376 17.0005
R7904 IOVDD.n792 IOVDD.n375 17.0005
R7905 IOVDD.n792 IOVDD.n374 17.0005
R7906 IOVDD.t93 IOVDD.n283 17.0005
R7907 IOVDD.t93 IOVDD.n284 17.0005
R7908 IOVDD.t93 IOVDD.n285 17.0005
R7909 IOVDD.t93 IOVDD.n286 17.0005
R7910 IOVDD.t93 IOVDD.n287 17.0005
R7911 IOVDD.t93 IOVDD.n288 17.0005
R7912 IOVDD.t93 IOVDD.n289 17.0005
R7913 IOVDD.t93 IOVDD.n290 17.0005
R7914 IOVDD.t93 IOVDD.n291 17.0005
R7915 IOVDD.t93 IOVDD.n292 17.0005
R7916 IOVDD.t93 IOVDD.n293 17.0005
R7917 IOVDD.t93 IOVDD.n294 17.0005
R7918 IOVDD.t93 IOVDD.n295 17.0005
R7919 IOVDD.n296 IOVDD.n283 17.0005
R7920 IOVDD.n296 IOVDD.n284 17.0005
R7921 IOVDD.n296 IOVDD.n285 17.0005
R7922 IOVDD.n296 IOVDD.n286 17.0005
R7923 IOVDD.n296 IOVDD.n287 17.0005
R7924 IOVDD.n296 IOVDD.n288 17.0005
R7925 IOVDD.n296 IOVDD.n289 17.0005
R7926 IOVDD.n296 IOVDD.n290 17.0005
R7927 IOVDD.n296 IOVDD.n291 17.0005
R7928 IOVDD.n296 IOVDD.n292 17.0005
R7929 IOVDD.n296 IOVDD.n293 17.0005
R7930 IOVDD.n296 IOVDD.n294 17.0005
R7931 IOVDD.n296 IOVDD.n295 17.0005
R7932 IOVDD.n802 IOVDD.n801 17.0005
R7933 IOVDD.n801 IOVDD.n800 17.0005
R7934 IOVDD.n796 IOVDD.n276 17.0005
R7935 IOVDD.n797 IOVDD.n796 17.0005
R7936 IOVDD.n306 IOVDD.n304 17.0005
R7937 IOVDD.n306 IOVDD.n305 17.0005
R7938 IOVDD.n317 IOVDD.n315 17.0005
R7939 IOVDD.n317 IOVDD.n316 17.0005
R7940 IOVDD.n321 IOVDD.n319 17.0005
R7941 IOVDD.n321 IOVDD.n320 17.0005
R7942 IOVDD.n325 IOVDD.n323 17.0005
R7943 IOVDD.n325 IOVDD.n324 17.0005
R7944 IOVDD.n329 IOVDD.n327 17.0005
R7945 IOVDD.n329 IOVDD.n328 17.0005
R7946 IOVDD.n775 IOVDD.n774 17.0005
R7947 IOVDD.n776 IOVDD.n775 17.0005
R7948 IOVDD.n334 IOVDD.n332 17.0005
R7949 IOVDD.n334 IOVDD.n333 17.0005
R7950 IOVDD.n338 IOVDD.n336 17.0005
R7951 IOVDD.n338 IOVDD.n337 17.0005
R7952 IOVDD.n342 IOVDD.n340 17.0005
R7953 IOVDD.n342 IOVDD.n341 17.0005
R7954 IOVDD.n346 IOVDD.n344 17.0005
R7955 IOVDD.n346 IOVDD.n345 17.0005
R7956 IOVDD.n350 IOVDD.n348 17.0005
R7957 IOVDD.n350 IOVDD.n349 17.0005
R7958 IOVDD.n354 IOVDD.n352 17.0005
R7959 IOVDD.n354 IOVDD.n353 17.0005
R7960 IOVDD.n517 IOVDD.n357 17.0005
R7961 IOVDD.n497 IOVDD.n357 17.0005
R7962 IOVDD.n791 IOVDD.n503 17.0005
R7963 IOVDD.n791 IOVDD.n505 17.0005
R7964 IOVDD.n791 IOVDD.n502 17.0005
R7965 IOVDD.n791 IOVDD.n506 17.0005
R7966 IOVDD.n791 IOVDD.n501 17.0005
R7967 IOVDD.n791 IOVDD.n507 17.0005
R7968 IOVDD.n791 IOVDD.n500 17.0005
R7969 IOVDD.n791 IOVDD.n508 17.0005
R7970 IOVDD.n791 IOVDD.n499 17.0005
R7971 IOVDD.n791 IOVDD.n790 17.0005
R7972 IOVDD.n791 IOVDD.n498 17.0005
R7973 IOVDD.n792 IOVDD.n791 17.0005
R7974 IOVDD.n1665 IOVDD.t145 17.0005
R7975 IOVDD.n198 IOVDD.t145 17.0005
R7976 IOVDD.n220 IOVDD.t145 17.0005
R7977 IOVDD.n199 IOVDD.t145 17.0005
R7978 IOVDD.n217 IOVDD.t145 17.0005
R7979 IOVDD.n200 IOVDD.t145 17.0005
R7980 IOVDD.n214 IOVDD.t145 17.0005
R7981 IOVDD.n201 IOVDD.t145 17.0005
R7982 IOVDD.n211 IOVDD.t145 17.0005
R7983 IOVDD.n202 IOVDD.t145 17.0005
R7984 IOVDD.n208 IOVDD.t145 17.0005
R7985 IOVDD.n203 IOVDD.t145 17.0005
R7986 IOVDD.n205 IOVDD.t145 17.0005
R7987 IOVDD.n1666 IOVDD.t145 17.0005
R7988 IOVDD.t146 IOVDD.n1665 17.0005
R7989 IOVDD.t146 IOVDD.n198 17.0005
R7990 IOVDD.t146 IOVDD.n220 17.0005
R7991 IOVDD.t146 IOVDD.n199 17.0005
R7992 IOVDD.t146 IOVDD.n217 17.0005
R7993 IOVDD.t146 IOVDD.n200 17.0005
R7994 IOVDD.t146 IOVDD.n214 17.0005
R7995 IOVDD.t146 IOVDD.n201 17.0005
R7996 IOVDD.t146 IOVDD.n211 17.0005
R7997 IOVDD.t146 IOVDD.n202 17.0005
R7998 IOVDD.t146 IOVDD.n208 17.0005
R7999 IOVDD.t146 IOVDD.n203 17.0005
R8000 IOVDD.t146 IOVDD.n205 17.0005
R8001 IOVDD.n1666 IOVDD.t146 17.0005
R8002 IOVDD.t174 IOVDD.n1658 17.0005
R8003 IOVDD.t174 IOVDD.n223 17.0005
R8004 IOVDD.t174 IOVDD.n245 17.0005
R8005 IOVDD.t174 IOVDD.n224 17.0005
R8006 IOVDD.t174 IOVDD.n242 17.0005
R8007 IOVDD.t174 IOVDD.n225 17.0005
R8008 IOVDD.t174 IOVDD.n239 17.0005
R8009 IOVDD.t174 IOVDD.n226 17.0005
R8010 IOVDD.t174 IOVDD.n236 17.0005
R8011 IOVDD.t174 IOVDD.n227 17.0005
R8012 IOVDD.t174 IOVDD.n233 17.0005
R8013 IOVDD.t174 IOVDD.n228 17.0005
R8014 IOVDD.t174 IOVDD.n230 17.0005
R8015 IOVDD.n1659 IOVDD.t174 17.0005
R8016 IOVDD.n1658 IOVDD.t175 17.0005
R8017 IOVDD.n223 IOVDD.t175 17.0005
R8018 IOVDD.n245 IOVDD.t175 17.0005
R8019 IOVDD.n224 IOVDD.t175 17.0005
R8020 IOVDD.n242 IOVDD.t175 17.0005
R8021 IOVDD.n225 IOVDD.t175 17.0005
R8022 IOVDD.n239 IOVDD.t175 17.0005
R8023 IOVDD.n226 IOVDD.t175 17.0005
R8024 IOVDD.n236 IOVDD.t175 17.0005
R8025 IOVDD.n227 IOVDD.t175 17.0005
R8026 IOVDD.n233 IOVDD.t175 17.0005
R8027 IOVDD.n228 IOVDD.t175 17.0005
R8028 IOVDD.n230 IOVDD.t175 17.0005
R8029 IOVDD.n1659 IOVDD.t175 17.0005
R8030 IOVDD.n194 IOVDD.t95 17.0005
R8031 IOVDD.n138 IOVDD.t95 17.0005
R8032 IOVDD.n160 IOVDD.t95 17.0005
R8033 IOVDD.n139 IOVDD.t95 17.0005
R8034 IOVDD.n157 IOVDD.t95 17.0005
R8035 IOVDD.n140 IOVDD.t95 17.0005
R8036 IOVDD.n154 IOVDD.t95 17.0005
R8037 IOVDD.n141 IOVDD.t95 17.0005
R8038 IOVDD.n151 IOVDD.t95 17.0005
R8039 IOVDD.n142 IOVDD.t95 17.0005
R8040 IOVDD.n148 IOVDD.t95 17.0005
R8041 IOVDD.n143 IOVDD.t95 17.0005
R8042 IOVDD.n145 IOVDD.t95 17.0005
R8043 IOVDD.n195 IOVDD.t95 17.0005
R8044 IOVDD.t96 IOVDD.n194 17.0005
R8045 IOVDD.t96 IOVDD.n138 17.0005
R8046 IOVDD.t96 IOVDD.n160 17.0005
R8047 IOVDD.t96 IOVDD.n139 17.0005
R8048 IOVDD.t96 IOVDD.n157 17.0005
R8049 IOVDD.t96 IOVDD.n140 17.0005
R8050 IOVDD.t96 IOVDD.n154 17.0005
R8051 IOVDD.t96 IOVDD.n141 17.0005
R8052 IOVDD.t96 IOVDD.n151 17.0005
R8053 IOVDD.t96 IOVDD.n142 17.0005
R8054 IOVDD.t96 IOVDD.n148 17.0005
R8055 IOVDD.t96 IOVDD.n143 17.0005
R8056 IOVDD.t96 IOVDD.n145 17.0005
R8057 IOVDD.n195 IOVDD.t96 17.0005
R8058 IOVDD.n163 IOVDD.t123 17.0005
R8059 IOVDD.n165 IOVDD.t123 17.0005
R8060 IOVDD.n167 IOVDD.t123 17.0005
R8061 IOVDD.n169 IOVDD.t123 17.0005
R8062 IOVDD.n171 IOVDD.t123 17.0005
R8063 IOVDD.n173 IOVDD.t123 17.0005
R8064 IOVDD.n175 IOVDD.t123 17.0005
R8065 IOVDD.n177 IOVDD.t123 17.0005
R8066 IOVDD.n179 IOVDD.t123 17.0005
R8067 IOVDD.n181 IOVDD.t123 17.0005
R8068 IOVDD.n183 IOVDD.t123 17.0005
R8069 IOVDD.n185 IOVDD.t123 17.0005
R8070 IOVDD.n187 IOVDD.t123 17.0005
R8071 IOVDD.n189 IOVDD.t123 17.0005
R8072 IOVDD.n163 IOVDD.t124 17.0005
R8073 IOVDD.n165 IOVDD.t124 17.0005
R8074 IOVDD.n167 IOVDD.t124 17.0005
R8075 IOVDD.n169 IOVDD.t124 17.0005
R8076 IOVDD.n171 IOVDD.t124 17.0005
R8077 IOVDD.n173 IOVDD.t124 17.0005
R8078 IOVDD.n175 IOVDD.t124 17.0005
R8079 IOVDD.n177 IOVDD.t124 17.0005
R8080 IOVDD.n179 IOVDD.t124 17.0005
R8081 IOVDD.n181 IOVDD.t124 17.0005
R8082 IOVDD.n183 IOVDD.t124 17.0005
R8083 IOVDD.n185 IOVDD.t124 17.0005
R8084 IOVDD.n187 IOVDD.t124 17.0005
R8085 IOVDD.n189 IOVDD.t124 17.0005
R8086 IOVDD.n164 IOVDD.n129 17.0005
R8087 IOVDD.n166 IOVDD.n129 17.0005
R8088 IOVDD.n168 IOVDD.n129 17.0005
R8089 IOVDD.n170 IOVDD.n129 17.0005
R8090 IOVDD.n172 IOVDD.n129 17.0005
R8091 IOVDD.n174 IOVDD.n129 17.0005
R8092 IOVDD.n176 IOVDD.n129 17.0005
R8093 IOVDD.n178 IOVDD.n129 17.0005
R8094 IOVDD.n180 IOVDD.n129 17.0005
R8095 IOVDD.n182 IOVDD.n129 17.0005
R8096 IOVDD.n184 IOVDD.n129 17.0005
R8097 IOVDD.n186 IOVDD.n129 17.0005
R8098 IOVDD.n190 IOVDD.n129 17.0005
R8099 IOVDD.n162 IOVDD.n129 17.0005
R8100 IOVDD.n161 IOVDD.n129 17.0005
R8101 IOVDD.n158 IOVDD.n129 17.0005
R8102 IOVDD.n159 IOVDD.n129 17.0005
R8103 IOVDD.n155 IOVDD.n129 17.0005
R8104 IOVDD.n156 IOVDD.n129 17.0005
R8105 IOVDD.n152 IOVDD.n129 17.0005
R8106 IOVDD.n153 IOVDD.n129 17.0005
R8107 IOVDD.n149 IOVDD.n129 17.0005
R8108 IOVDD.n150 IOVDD.n129 17.0005
R8109 IOVDD.n146 IOVDD.n129 17.0005
R8110 IOVDD.n147 IOVDD.n129 17.0005
R8111 IOVDD.n144 IOVDD.n129 17.0005
R8112 IOVDD.n137 IOVDD.n129 17.0005
R8113 IOVDD.n197 IOVDD.n129 17.0005
R8114 IOVDD.n204 IOVDD.n129 17.0005
R8115 IOVDD.n207 IOVDD.n129 17.0005
R8116 IOVDD.n206 IOVDD.n129 17.0005
R8117 IOVDD.n210 IOVDD.n129 17.0005
R8118 IOVDD.n209 IOVDD.n129 17.0005
R8119 IOVDD.n213 IOVDD.n129 17.0005
R8120 IOVDD.n212 IOVDD.n129 17.0005
R8121 IOVDD.n216 IOVDD.n129 17.0005
R8122 IOVDD.n215 IOVDD.n129 17.0005
R8123 IOVDD.n219 IOVDD.n129 17.0005
R8124 IOVDD.n218 IOVDD.n129 17.0005
R8125 IOVDD.n1663 IOVDD.n129 17.0005
R8126 IOVDD.n221 IOVDD.n129 17.0005
R8127 IOVDD.n222 IOVDD.n129 17.0005
R8128 IOVDD.n229 IOVDD.n129 17.0005
R8129 IOVDD.n232 IOVDD.n129 17.0005
R8130 IOVDD.n231 IOVDD.n129 17.0005
R8131 IOVDD.n235 IOVDD.n129 17.0005
R8132 IOVDD.n234 IOVDD.n129 17.0005
R8133 IOVDD.n238 IOVDD.n129 17.0005
R8134 IOVDD.n237 IOVDD.n129 17.0005
R8135 IOVDD.n241 IOVDD.n129 17.0005
R8136 IOVDD.n240 IOVDD.n129 17.0005
R8137 IOVDD.n244 IOVDD.n129 17.0005
R8138 IOVDD.n243 IOVDD.n129 17.0005
R8139 IOVDD.n1657 IOVDD.n129 17.0005
R8140 IOVDD.n135 IOVDD.n129 17.0005
R8141 IOVDD.n31 IOVDD.t2 17.0005
R8142 IOVDD.n18 IOVDD.t2 17.0005
R8143 IOVDD.n30 IOVDD.t2 17.0005
R8144 IOVDD.n19 IOVDD.t2 17.0005
R8145 IOVDD.n29 IOVDD.t2 17.0005
R8146 IOVDD.n20 IOVDD.t2 17.0005
R8147 IOVDD.n28 IOVDD.t2 17.0005
R8148 IOVDD.n21 IOVDD.t2 17.0005
R8149 IOVDD.n27 IOVDD.t2 17.0005
R8150 IOVDD.n22 IOVDD.t2 17.0005
R8151 IOVDD.n26 IOVDD.t2 17.0005
R8152 IOVDD.n23 IOVDD.t2 17.0005
R8153 IOVDD.n25 IOVDD.t2 17.0005
R8154 IOVDD.n24 IOVDD.t2 17.0005
R8155 IOVDD.n31 IOVDD.t120 17.0005
R8156 IOVDD.t120 IOVDD.n18 17.0005
R8157 IOVDD.t120 IOVDD.n30 17.0005
R8158 IOVDD.t120 IOVDD.n19 17.0005
R8159 IOVDD.t120 IOVDD.n29 17.0005
R8160 IOVDD.t120 IOVDD.n20 17.0005
R8161 IOVDD.t120 IOVDD.n28 17.0005
R8162 IOVDD.t120 IOVDD.n21 17.0005
R8163 IOVDD.t120 IOVDD.n27 17.0005
R8164 IOVDD.t120 IOVDD.n22 17.0005
R8165 IOVDD.t120 IOVDD.n26 17.0005
R8166 IOVDD.t120 IOVDD.n23 17.0005
R8167 IOVDD.t120 IOVDD.n25 17.0005
R8168 IOVDD.t120 IOVDD.n24 17.0005
R8169 IOVDD.n31 IOVDD.t121 17.0005
R8170 IOVDD.n18 IOVDD.t121 17.0005
R8171 IOVDD.n30 IOVDD.t121 17.0005
R8172 IOVDD.n19 IOVDD.t121 17.0005
R8173 IOVDD.n29 IOVDD.t121 17.0005
R8174 IOVDD.n20 IOVDD.t121 17.0005
R8175 IOVDD.n28 IOVDD.t121 17.0005
R8176 IOVDD.n21 IOVDD.t121 17.0005
R8177 IOVDD.n27 IOVDD.t121 17.0005
R8178 IOVDD.n22 IOVDD.t121 17.0005
R8179 IOVDD.n26 IOVDD.t121 17.0005
R8180 IOVDD.n23 IOVDD.t121 17.0005
R8181 IOVDD.n25 IOVDD.t121 17.0005
R8182 IOVDD.n24 IOVDD.t121 17.0005
R8183 IOVDD.n63 IOVDD.t28 17.0005
R8184 IOVDD.n50 IOVDD.t28 17.0005
R8185 IOVDD.n62 IOVDD.t28 17.0005
R8186 IOVDD.n51 IOVDD.t28 17.0005
R8187 IOVDD.n61 IOVDD.t28 17.0005
R8188 IOVDD.n52 IOVDD.t28 17.0005
R8189 IOVDD.n60 IOVDD.t28 17.0005
R8190 IOVDD.n53 IOVDD.t28 17.0005
R8191 IOVDD.n59 IOVDD.t28 17.0005
R8192 IOVDD.n54 IOVDD.t28 17.0005
R8193 IOVDD.n58 IOVDD.t28 17.0005
R8194 IOVDD.n55 IOVDD.t28 17.0005
R8195 IOVDD.n57 IOVDD.t28 17.0005
R8196 IOVDD.n56 IOVDD.t28 17.0005
R8197 IOVDD.n63 IOVDD.t150 17.0005
R8198 IOVDD.n50 IOVDD.t150 17.0005
R8199 IOVDD.n62 IOVDD.t150 17.0005
R8200 IOVDD.n51 IOVDD.t150 17.0005
R8201 IOVDD.n61 IOVDD.t150 17.0005
R8202 IOVDD.n52 IOVDD.t150 17.0005
R8203 IOVDD.n60 IOVDD.t150 17.0005
R8204 IOVDD.n53 IOVDD.t150 17.0005
R8205 IOVDD.n59 IOVDD.t150 17.0005
R8206 IOVDD.n54 IOVDD.t150 17.0005
R8207 IOVDD.n58 IOVDD.t150 17.0005
R8208 IOVDD.n55 IOVDD.t150 17.0005
R8209 IOVDD.n57 IOVDD.t150 17.0005
R8210 IOVDD.n56 IOVDD.t150 17.0005
R8211 IOVDD.n63 IOVDD.t151 17.0005
R8212 IOVDD.t151 IOVDD.n50 17.0005
R8213 IOVDD.t151 IOVDD.n62 17.0005
R8214 IOVDD.t151 IOVDD.n51 17.0005
R8215 IOVDD.t151 IOVDD.n61 17.0005
R8216 IOVDD.t151 IOVDD.n52 17.0005
R8217 IOVDD.t151 IOVDD.n60 17.0005
R8218 IOVDD.t151 IOVDD.n53 17.0005
R8219 IOVDD.t151 IOVDD.n59 17.0005
R8220 IOVDD.t151 IOVDD.n54 17.0005
R8221 IOVDD.t151 IOVDD.n58 17.0005
R8222 IOVDD.t151 IOVDD.n55 17.0005
R8223 IOVDD.t151 IOVDD.n57 17.0005
R8224 IOVDD.t151 IOVDD.n56 17.0005
R8225 IOVDD.n1677 IOVDD.n5 17.0005
R8226 IOVDD.n1677 IOVDD.n6 17.0005
R8227 IOVDD.n1677 IOVDD.n7 17.0005
R8228 IOVDD.n1677 IOVDD.n8 17.0005
R8229 IOVDD.n1677 IOVDD.n9 17.0005
R8230 IOVDD.n1677 IOVDD.n10 17.0005
R8231 IOVDD.n1677 IOVDD.n11 17.0005
R8232 IOVDD.n1677 IOVDD.n12 17.0005
R8233 IOVDD.n1677 IOVDD.n13 17.0005
R8234 IOVDD.n1677 IOVDD.n14 17.0005
R8235 IOVDD.n1677 IOVDD.n15 17.0005
R8236 IOVDD.n1677 IOVDD.n16 17.0005
R8237 IOVDD.n1677 IOVDD.n32 17.0005
R8238 IOVDD.n1677 IOVDD.n33 17.0005
R8239 IOVDD.n1677 IOVDD.n37 17.0005
R8240 IOVDD.n1677 IOVDD.n38 17.0005
R8241 IOVDD.n1677 IOVDD.n39 17.0005
R8242 IOVDD.n1677 IOVDD.n40 17.0005
R8243 IOVDD.n1677 IOVDD.n41 17.0005
R8244 IOVDD.n1677 IOVDD.n42 17.0005
R8245 IOVDD.n1677 IOVDD.n43 17.0005
R8246 IOVDD.n1677 IOVDD.n44 17.0005
R8247 IOVDD.n1677 IOVDD.n45 17.0005
R8248 IOVDD.n1677 IOVDD.n46 17.0005
R8249 IOVDD.n1677 IOVDD.n47 17.0005
R8250 IOVDD.n1677 IOVDD.n48 17.0005
R8251 IOVDD.n1677 IOVDD.n49 17.0005
R8252 IOVDD.n93 IOVDD.t139 17.0005
R8253 IOVDD.n80 IOVDD.t139 17.0005
R8254 IOVDD.n92 IOVDD.t139 17.0005
R8255 IOVDD.n81 IOVDD.t139 17.0005
R8256 IOVDD.n91 IOVDD.t139 17.0005
R8257 IOVDD.n82 IOVDD.t139 17.0005
R8258 IOVDD.n90 IOVDD.t139 17.0005
R8259 IOVDD.n83 IOVDD.t139 17.0005
R8260 IOVDD.n89 IOVDD.t139 17.0005
R8261 IOVDD.n84 IOVDD.t139 17.0005
R8262 IOVDD.n88 IOVDD.t139 17.0005
R8263 IOVDD.n85 IOVDD.t139 17.0005
R8264 IOVDD.n87 IOVDD.t139 17.0005
R8265 IOVDD.n86 IOVDD.t139 17.0005
R8266 IOVDD.n93 IOVDD.t140 17.0005
R8267 IOVDD.t140 IOVDD.n80 17.0005
R8268 IOVDD.t140 IOVDD.n92 17.0005
R8269 IOVDD.t140 IOVDD.n81 17.0005
R8270 IOVDD.t140 IOVDD.n91 17.0005
R8271 IOVDD.t140 IOVDD.n82 17.0005
R8272 IOVDD.t140 IOVDD.n90 17.0005
R8273 IOVDD.t140 IOVDD.n83 17.0005
R8274 IOVDD.t140 IOVDD.n89 17.0005
R8275 IOVDD.t140 IOVDD.n84 17.0005
R8276 IOVDD.t140 IOVDD.n88 17.0005
R8277 IOVDD.t140 IOVDD.n85 17.0005
R8278 IOVDD.t140 IOVDD.n87 17.0005
R8279 IOVDD.t140 IOVDD.n86 17.0005
R8280 IOVDD.n93 IOVDD.t29 17.0005
R8281 IOVDD.n80 IOVDD.t29 17.0005
R8282 IOVDD.n92 IOVDD.t29 17.0005
R8283 IOVDD.n81 IOVDD.t29 17.0005
R8284 IOVDD.n91 IOVDD.t29 17.0005
R8285 IOVDD.n82 IOVDD.t29 17.0005
R8286 IOVDD.n90 IOVDD.t29 17.0005
R8287 IOVDD.n83 IOVDD.t29 17.0005
R8288 IOVDD.n89 IOVDD.t29 17.0005
R8289 IOVDD.n84 IOVDD.t29 17.0005
R8290 IOVDD.n88 IOVDD.t29 17.0005
R8291 IOVDD.n85 IOVDD.t29 17.0005
R8292 IOVDD.n87 IOVDD.t29 17.0005
R8293 IOVDD.n86 IOVDD.t29 17.0005
R8294 IOVDD.n125 IOVDD.t40 17.0005
R8295 IOVDD.n112 IOVDD.t40 17.0005
R8296 IOVDD.n124 IOVDD.t40 17.0005
R8297 IOVDD.n113 IOVDD.t40 17.0005
R8298 IOVDD.n123 IOVDD.t40 17.0005
R8299 IOVDD.n114 IOVDD.t40 17.0005
R8300 IOVDD.n122 IOVDD.t40 17.0005
R8301 IOVDD.n115 IOVDD.t40 17.0005
R8302 IOVDD.n121 IOVDD.t40 17.0005
R8303 IOVDD.n116 IOVDD.t40 17.0005
R8304 IOVDD.n120 IOVDD.t40 17.0005
R8305 IOVDD.n117 IOVDD.t40 17.0005
R8306 IOVDD.n119 IOVDD.t40 17.0005
R8307 IOVDD.n118 IOVDD.t40 17.0005
R8308 IOVDD.n125 IOVDD.t41 17.0005
R8309 IOVDD.n112 IOVDD.t41 17.0005
R8310 IOVDD.n124 IOVDD.t41 17.0005
R8311 IOVDD.n113 IOVDD.t41 17.0005
R8312 IOVDD.n123 IOVDD.t41 17.0005
R8313 IOVDD.n114 IOVDD.t41 17.0005
R8314 IOVDD.n122 IOVDD.t41 17.0005
R8315 IOVDD.n115 IOVDD.t41 17.0005
R8316 IOVDD.n121 IOVDD.t41 17.0005
R8317 IOVDD.n116 IOVDD.t41 17.0005
R8318 IOVDD.n120 IOVDD.t41 17.0005
R8319 IOVDD.n117 IOVDD.t41 17.0005
R8320 IOVDD.n119 IOVDD.t41 17.0005
R8321 IOVDD.n118 IOVDD.t41 17.0005
R8322 IOVDD.n125 IOVDD.t30 17.0005
R8323 IOVDD.t30 IOVDD.n112 17.0005
R8324 IOVDD.t30 IOVDD.n124 17.0005
R8325 IOVDD.t30 IOVDD.n113 17.0005
R8326 IOVDD.t30 IOVDD.n123 17.0005
R8327 IOVDD.t30 IOVDD.n114 17.0005
R8328 IOVDD.t30 IOVDD.n122 17.0005
R8329 IOVDD.t30 IOVDD.n115 17.0005
R8330 IOVDD.t30 IOVDD.n121 17.0005
R8331 IOVDD.t30 IOVDD.n116 17.0005
R8332 IOVDD.t30 IOVDD.n120 17.0005
R8333 IOVDD.t30 IOVDD.n117 17.0005
R8334 IOVDD.t30 IOVDD.n119 17.0005
R8335 IOVDD.t30 IOVDD.n118 17.0005
R8336 IOVDD.n1677 IOVDD.n111 17.0005
R8337 IOVDD.n1677 IOVDD.n110 17.0005
R8338 IOVDD.n1677 IOVDD.n109 17.0005
R8339 IOVDD.n1677 IOVDD.n108 17.0005
R8340 IOVDD.n1677 IOVDD.n107 17.0005
R8341 IOVDD.n1677 IOVDD.n106 17.0005
R8342 IOVDD.n1677 IOVDD.n105 17.0005
R8343 IOVDD.n1677 IOVDD.n104 17.0005
R8344 IOVDD.n1677 IOVDD.n103 17.0005
R8345 IOVDD.n1677 IOVDD.n102 17.0005
R8346 IOVDD.n1677 IOVDD.n101 17.0005
R8347 IOVDD.n1677 IOVDD.n100 17.0005
R8348 IOVDD.n1677 IOVDD.n99 17.0005
R8349 IOVDD.n1677 IOVDD.n95 17.0005
R8350 IOVDD.n1677 IOVDD.n94 17.0005
R8351 IOVDD.n1677 IOVDD.n78 17.0005
R8352 IOVDD.n1677 IOVDD.n77 17.0005
R8353 IOVDD.n1677 IOVDD.n76 17.0005
R8354 IOVDD.n1677 IOVDD.n75 17.0005
R8355 IOVDD.n1677 IOVDD.n74 17.0005
R8356 IOVDD.n1677 IOVDD.n73 17.0005
R8357 IOVDD.n1677 IOVDD.n72 17.0005
R8358 IOVDD.n1677 IOVDD.n71 17.0005
R8359 IOVDD.n1677 IOVDD.n70 17.0005
R8360 IOVDD.n1677 IOVDD.n69 17.0005
R8361 IOVDD.n1677 IOVDD.n68 17.0005
R8362 IOVDD.n1677 IOVDD.n67 17.0005
R8363 IOVDD.n1678 IOVDD.n1677 17.0005
R8364 IOVDD.n685 IOVDD.n683 15.0005
R8365 IOVDD.n687 IOVDD.n683 15.0005
R8366 IOVDD.t114 IOVDD.n514 15.0005
R8367 IOVDD.n1547 IOVDD.n1508 13.1785
R8368 IOVDD.n538 IOVDD.t221 11.2202
R8369 IOVDD.n803 IOVDD.t220 11.2199
R8370 IOVDD.n1407 IOVDD.n1406 8.55834
R8371 IOVDD.n957 IOVDD.n899 8.501
R8372 IOVDD.n1548 IOVDD.n958 8.501
R8373 IOVDD.n956 IOVDD.n902 8.501
R8374 IOVDD.n1548 IOVDD.n955 8.501
R8375 IOVDD.n954 IOVDD.n953 8.501
R8376 IOVDD.n1548 IOVDD.n952 8.501
R8377 IOVDD.n1551 IOVDD.n1550 8.501
R8378 IOVDD.n1549 IOVDD.n1548 8.501
R8379 IOVDD.n895 IOVDD.n853 8.501
R8380 IOVDD.n1526 IOVDD.n903 8.501
R8381 IOVDD.n840 IOVDD.n818 8.501
R8382 IOVDD.n535 IOVDD.n534 8.501
R8383 IOVDD.n535 IOVDD.n532 8.501
R8384 IOVDD.n535 IOVDD.n531 8.501
R8385 IOVDD.n535 IOVDD.n530 8.501
R8386 IOVDD.n535 IOVDD.n529 8.501
R8387 IOVDD.n535 IOVDD.n528 8.501
R8388 IOVDD.n535 IOVDD.n527 8.501
R8389 IOVDD.n535 IOVDD.n526 8.501
R8390 IOVDD.n535 IOVDD.n525 8.501
R8391 IOVDD.n535 IOVDD.n524 8.501
R8392 IOVDD.n535 IOVDD.n523 8.501
R8393 IOVDD.n535 IOVDD.n522 8.501
R8394 IOVDD.n535 IOVDD.n521 8.501
R8395 IOVDD.n535 IOVDD.n312 8.501
R8396 IOVDD.n764 IOVDD.n608 8.501
R8397 IOVDD.n764 IOVDD.n615 8.501
R8398 IOVDD.n764 IOVDD.n613 8.501
R8399 IOVDD.n764 IOVDD.n612 8.501
R8400 IOVDD.n764 IOVDD.n610 8.501
R8401 IOVDD.n764 IOVDD.n606 8.501
R8402 IOVDD.n763 IOVDD.n762 8.501
R8403 IOVDD.n762 IOVDD.n760 8.501
R8404 IOVDD.n762 IOVDD.n758 8.501
R8405 IOVDD.n762 IOVDD.n756 8.501
R8406 IOVDD.n762 IOVDD.n754 8.501
R8407 IOVDD.n762 IOVDD.n752 8.501
R8408 IOVDD.n762 IOVDD.n750 8.501
R8409 IOVDD.n788 IOVDD.n787 8.501
R8410 IOVDD.n788 IOVDD.n786 8.501
R8411 IOVDD.n788 IOVDD.n785 8.501
R8412 IOVDD.n788 IOVDD.n784 8.501
R8413 IOVDD.n789 IOVDD.n788 8.501
R8414 IOVDD.t50 IOVDD.n274 8.501
R8415 IOVDD.n777 IOVDD.n297 8.501
R8416 IOVDD.t50 IOVDD.n275 8.501
R8417 IOVDD.n795 IOVDD.t50 8.501
R8418 IOVDD.t50 IOVDD.n314 8.501
R8419 IOVDD.t50 IOVDD.n318 8.501
R8420 IOVDD.t50 IOVDD.n322 8.501
R8421 IOVDD.t50 IOVDD.n326 8.501
R8422 IOVDD.t50 IOVDD.n330 8.501
R8423 IOVDD.t50 IOVDD.n331 8.501
R8424 IOVDD.t50 IOVDD.n335 8.501
R8425 IOVDD.t50 IOVDD.n339 8.501
R8426 IOVDD.t50 IOVDD.n343 8.501
R8427 IOVDD.t50 IOVDD.n347 8.501
R8428 IOVDD.t50 IOVDD.n351 8.501
R8429 IOVDD.t50 IOVDD.n355 8.501
R8430 IOVDD.t50 IOVDD.n356 8.501
R8431 IOVDD.n1674 IOVDD.n133 8.501
R8432 IOVDD.n1674 IOVDD.n132 8.501
R8433 IOVDD.n1675 IOVDD.n1674 8.501
R8434 IOVDD.n1567 IOVDD.t69 8.5005
R8435 IOVDD.n1567 IOVDD.t62 8.5005
R8436 IOVDD.t69 IOVDD.n901 8.5005
R8437 IOVDD.n901 IOVDD.t62 8.5005
R8438 IOVDD.n951 IOVDD.n901 8.5005
R8439 IOVDD.t69 IOVDD.n1553 8.5005
R8440 IOVDD.n1553 IOVDD.t62 8.5005
R8441 IOVDD.n1576 IOVDD.n818 8.5005
R8442 IOVDD.n792 IOVDD.n362 8.5005
R8443 IOVDD.n792 IOVDD.n363 8.5005
R8444 IOVDD.n792 IOVDD.n364 8.5005
R8445 IOVDD.n792 IOVDD.n366 8.5005
R8446 IOVDD.n792 IOVDD.t4 8.5005
R8447 IOVDD.n792 IOVDD.n367 8.5005
R8448 IOVDD.n792 IOVDD.n368 8.5005
R8449 IOVDD.n792 IOVDD.n369 8.5005
R8450 IOVDD.n792 IOVDD.t24 8.5005
R8451 IOVDD.n792 IOVDD.t0 8.5005
R8452 IOVDD.n792 IOVDD.n370 8.5005
R8453 IOVDD.n792 IOVDD.t22 8.5005
R8454 IOVDD.n792 IOVDD.n371 8.5005
R8455 IOVDD.n792 IOVDD.n372 8.5005
R8456 IOVDD.n792 IOVDD.n373 8.5005
R8457 IOVDD.n603 IOVDD.t14 8.5005
R8458 IOVDD.n575 IOVDD.t14 8.5005
R8459 IOVDD.n602 IOVDD.t14 8.5005
R8460 IOVDD.n576 IOVDD.t14 8.5005
R8461 IOVDD.n601 IOVDD.t14 8.5005
R8462 IOVDD.n577 IOVDD.t14 8.5005
R8463 IOVDD.n600 IOVDD.t14 8.5005
R8464 IOVDD.n578 IOVDD.t14 8.5005
R8465 IOVDD.n599 IOVDD.t14 8.5005
R8466 IOVDD.n579 IOVDD.t14 8.5005
R8467 IOVDD.n598 IOVDD.t14 8.5005
R8468 IOVDD.n580 IOVDD.t14 8.5005
R8469 IOVDD.n597 IOVDD.t14 8.5005
R8470 IOVDD.n581 IOVDD.t14 8.5005
R8471 IOVDD.n582 IOVDD.t14 8.5005
R8472 IOVDD.n584 IOVDD.t14 8.5005
R8473 IOVDD.n596 IOVDD.t14 8.5005
R8474 IOVDD.n585 IOVDD.t14 8.5005
R8475 IOVDD.n595 IOVDD.t14 8.5005
R8476 IOVDD.n586 IOVDD.t14 8.5005
R8477 IOVDD.n594 IOVDD.t14 8.5005
R8478 IOVDD.n587 IOVDD.t14 8.5005
R8479 IOVDD.n593 IOVDD.t14 8.5005
R8480 IOVDD.n588 IOVDD.t14 8.5005
R8481 IOVDD.n592 IOVDD.t14 8.5005
R8482 IOVDD.n589 IOVDD.t14 8.5005
R8483 IOVDD.n591 IOVDD.t14 8.5005
R8484 IOVDD.n590 IOVDD.t14 8.5005
R8485 IOVDD.n604 IOVDD.t14 8.5005
R8486 IOVDD.n792 IOVDD.n360 8.5005
R8487 IOVDD.n792 IOVDD.n361 8.5005
R8488 IOVDD.n748 IOVDD.n360 8.5005
R8489 IOVDD.n748 IOVDD.n512 8.5005
R8490 IOVDD.n748 IOVDD.t33 8.5005
R8491 IOVDD.n759 IOVDD.n512 8.5005
R8492 IOVDD.n757 IOVDD.n512 8.5005
R8493 IOVDD.n755 IOVDD.t156 8.5005
R8494 IOVDD.n755 IOVDD.n512 8.5005
R8495 IOVDD.n755 IOVDD.n361 8.5005
R8496 IOVDD.n753 IOVDD.n361 8.5005
R8497 IOVDD.n753 IOVDD.n512 8.5005
R8498 IOVDD.n753 IOVDD.n362 8.5005
R8499 IOVDD.n751 IOVDD.n362 8.5005
R8500 IOVDD.n751 IOVDD.n512 8.5005
R8501 IOVDD.n751 IOVDD.t130 8.5005
R8502 IOVDD.n749 IOVDD.n512 8.5005
R8503 IOVDD.n783 IOVDD.n512 8.5005
R8504 IOVDD.n788 IOVDD.n783 8.5005
R8505 IOVDD.t93 IOVDD.n298 8.5005
R8506 IOVDD.t93 IOVDD.n282 8.5005
R8507 IOVDD.t93 IOVDD.n299 8.5005
R8508 IOVDD.t93 IOVDD.n281 8.5005
R8509 IOVDD.t93 IOVDD.n300 8.5005
R8510 IOVDD.t93 IOVDD.n280 8.5005
R8511 IOVDD.t93 IOVDD.n301 8.5005
R8512 IOVDD.t93 IOVDD.n279 8.5005
R8513 IOVDD.t93 IOVDD.n302 8.5005
R8514 IOVDD.t93 IOVDD.n278 8.5005
R8515 IOVDD.t93 IOVDD.n303 8.5005
R8516 IOVDD.t93 IOVDD.n277 8.5005
R8517 IOVDD.t93 IOVDD.n798 8.5005
R8518 IOVDD.n799 IOVDD.t93 8.5005
R8519 IOVDD.t93 IOVDD.n273 8.5005
R8520 IOVDD.t1 IOVDD.n130 8.5005
R8521 IOVDD.t1 IOVDD.n131 8.5005
R8522 IOVDD.t1 IOVDD.n1676 8.5005
R8523 IOVDD.n792 IOVDD.n437 8.50035
R8524 IOVDD.n792 IOVDD.n431 8.50035
R8525 IOVDD.n764 IOVDD.n673 8.50004
R8526 IOVDD.n764 IOVDD.n688 8.50004
R8527 IOVDD.n764 IOVDD.n547 8.49954
R8528 IOVDD.n765 IOVDD.n764 8.49954
R8529 IOVDD.t157 IOVDD.n583 8.4995
R8530 IOVDD.n1553 IOVDD.n932 8.49931
R8531 IOVDD.n1553 IOVDD.n908 8.49931
R8532 IOVDD.n1567 IOVDD.n855 8.49931
R8533 IOVDD.n1567 IOVDD.n879 8.49931
R8534 IOVDD.n1544 IOVDD.n901 8.49914
R8535 IOVDD.n1540 IOVDD.n901 8.49914
R8536 IOVDD.n1538 IOVDD.n901 8.49914
R8537 IOVDD.n1534 IOVDD.n901 8.49914
R8538 IOVDD.n1576 IOVDD.n826 8.49914
R8539 IOVDD.n1576 IOVDD.n824 8.49914
R8540 IOVDD.n1576 IOVDD.n836 8.49914
R8541 IOVDD.n1576 IOVDD.n822 8.49914
R8542 IOVDD.n804 IOVDD.n272 8.49896
R8543 IOVDD.n516 IOVDD.n515 8.49896
R8544 IOVDD.n1052 IOVDD.n962 8.49868
R8545 IOVDD.n1414 IOVDD.n962 8.49868
R8546 IOVDD.n1000 IOVDD.n962 8.49868
R8547 IOVDD.n992 IOVDD.n962 8.49868
R8548 IOVDD.n968 IOVDD.n962 8.49868
R8549 IOVDD.n1445 IOVDD.n962 8.49868
R8550 IOVDD.n1503 IOVDD.n962 8.49868
R8551 IOVDD.n1400 IOVDD.n1108 8.49868
R8552 IOVDD.n1400 IOVDD.n1151 8.49868
R8553 IOVDD.n1400 IOVDD.n1163 8.49868
R8554 IOVDD.n1400 IOVDD.n1166 8.49868
R8555 IOVDD.n1401 IOVDD.n1400 8.49868
R8556 IOVDD.n1400 IOVDD.n1221 8.49868
R8557 IOVDD.n1398 IOVDD.n1364 8.49864
R8558 IOVDD.n1398 IOVDD.n1343 8.49864
R8559 IOVDD.n1398 IOVDD.n1303 8.49864
R8560 IOVDD.n1398 IOVDD.n1296 8.49864
R8561 IOVDD.n998 IOVDD.t27 8.49861
R8562 IOVDD.n1194 IOVDD.t6 8.49861
R8563 IOVDD.n1677 IOVDD.n17 8.49844
R8564 IOVDD.n1677 IOVDD.n36 8.49844
R8565 IOVDD.n1677 IOVDD.n98 8.49844
R8566 IOVDD.n1677 IOVDD.n79 8.49844
R8567 IOVDD.n188 IOVDD.n129 8.49791
R8568 IOVDD.n193 IOVDD.n129 8.49791
R8569 IOVDD.n1664 IOVDD.n129 8.49791
R8570 IOVDD.n1660 IOVDD.n129 8.49791
R8571 IOVDD.t180 IOVDD.n848 8.4937
R8572 IOVDD.n849 IOVDD.t180 8.4937
R8573 IOVDD.t180 IOVDD.n845 8.4937
R8574 IOVDD.t182 IOVDD.n846 8.4937
R8575 IOVDD.t182 IOVDD.n847 8.4937
R8576 IOVDD.n1536 IOVDD.n1535 7.50133
R8577 IOVDD.n833 IOVDD.n828 7.50133
R8578 IOVDD.n546 IOVDD.n541 7.501
R8579 IOVDD.n680 IOVDD.n678 7.501
R8580 IOVDD.t60 IOVDD.n1560 7.5005
R8581 IOVDD.t60 IOVDD.n1559 7.5005
R8582 IOVDD.t60 IOVDD.n1558 7.5005
R8583 IOVDD.n1562 IOVDD.t60 7.5005
R8584 IOVDD.t60 IOVDD.n1561 7.5005
R8585 IOVDD.n907 IOVDD.t141 7.5005
R8586 IOVDD.n906 IOVDD.t141 7.5005
R8587 IOVDD.n907 IOVDD.t68 7.5005
R8588 IOVDD.t68 IOVDD.n906 7.5005
R8589 IOVDD.n935 IOVDD.t42 7.5005
R8590 IOVDD.n934 IOVDD.t42 7.5005
R8591 IOVDD.n935 IOVDD.t108 7.5005
R8592 IOVDD.t108 IOVDD.n934 7.5005
R8593 IOVDD.n881 IOVDD.t100 7.5005
R8594 IOVDD.n882 IOVDD.t100 7.5005
R8595 IOVDD.t161 IOVDD.n881 7.5005
R8596 IOVDD.n882 IOVDD.t161 7.5005
R8597 IOVDD.n1563 IOVDD.t56 7.5005
R8598 IOVDD.n1564 IOVDD.t56 7.5005
R8599 IOVDD.t125 IOVDD.n1563 7.5005
R8600 IOVDD.n1564 IOVDD.t125 7.5005
R8601 IOVDD.n544 IOVDD.t155 7.5005
R8602 IOVDD.n544 IOVDD.n543 7.5005
R8603 IOVDD.n681 IOVDD.n676 7.5005
R8604 IOVDD.n683 IOVDD.n676 7.5005
R8605 IOVDD.t144 IOVDD.n1661 7.5005
R8606 IOVDD.n1662 IOVDD.t144 7.5005
R8607 IOVDD.t94 IOVDD.n191 7.5005
R8608 IOVDD.n192 IOVDD.t94 7.5005
R8609 IOVDD.n35 IOVDD.t119 7.5005
R8610 IOVDD.t119 IOVDD.n34 7.5005
R8611 IOVDD.n97 IOVDD.t39 7.5005
R8612 IOVDD.t39 IOVDD.n96 7.5005
R8613 IOVDD.n1548 IOVDD.n819 5.66778
R8614 IOVDD.n773 IOVDD.n520 5.66778
R8615 IOVDD.n762 IOVDD.n513 5.66778
R8616 IOVDD.n782 IOVDD.n780 5.66778
R8617 IOVDD.n1674 IOVDD.n134 5.66778
R8618 IOVDD.n764 IOVDD.n607 5.66767
R8619 IOVDD.n764 IOVDD.n614 5.66767
R8620 IOVDD.n764 IOVDD.n611 5.66767
R8621 IOVDD.n1400 IOVDD.n960 5.66717
R8622 IOVDD.n1574 IOVDD.n1573 5.66717
R8623 IOVDD.n1573 IOVDD.n1572 5.66717
R8624 IOVDD.n1573 IOVDD.n842 5.66717
R8625 IOVDD.n792 IOVDD.t130 5.66717
R8626 IOVDD.n792 IOVDD.t13 5.66717
R8627 IOVDD.n792 IOVDD.t31 5.66717
R8628 IOVDD.n792 IOVDD.t156 5.66717
R8629 IOVDD.n783 IOVDD.n365 5.66717
R8630 IOVDD.n764 IOVDD.n539 5.66648
R8631 IOVDD.n1553 IOVDD.n904 5.66617
R8632 IOVDD.n1400 IOVDD.n1093 5.66366
R8633 IOVDD.n1656 IOVDD.n129 5.6623
R8634 IOVDD.n767 IOVDD.n535 5.6544
R8635 IOVDD.n1677 IOVDD.n2 5.65366
R8636 IOVDD.n1394 IOVDD.n962 5.65242
R8637 IOVDD.n1398 IOVDD.n1378 5.6423
R8638 IOVDD.n1576 IOVDD.n821 5.62406
R8639 IOVDD.n1525 IOVDD.n1524 5.61281
R8640 IOVDD.n1543 IOVDD.n1510 5.00237
R8641 IOVDD.n831 IOVDD.n829 5.00219
R8642 IOVDD.n546 IOVDD.n545 5.00219
R8643 IOVDD.n1537 IOVDD.n1536 5.00111
R8644 IOVDD.n835 IOVDD.n828 5.00111
R8645 IOVDD.n682 IOVDD.n678 5.00111
R8646 IOVDD.n546 IOVDD.n542 5.001
R8647 IOVDD.t92 IOVDD.n514 5.0005
R8648 IOVDD.n1502 IOVDD.n1501 4.87342
R8649 IOVDD.n1495 IOVDD.t216 4.74494
R8650 IOVDD.n1475 IOVDD.t191 4.74494
R8651 IOVDD.n1481 IOVDD.t194 4.74494
R8652 IOVDD.n1488 IOVDD.t213 4.74494
R8653 IOVDD.n1500 IOVDD.n1499 4.61534
R8654 IOVDD.n1499 IOVDD.n1498 4.61534
R8655 IOVDD.n1498 IOVDD.n1497 4.61534
R8656 IOVDD.n1497 IOVDD.n1496 4.61534
R8657 IOVDD.n1496 IOVDD.n1495 4.61534
R8658 IOVDD.n1480 IOVDD.n1479 4.61534
R8659 IOVDD.n1479 IOVDD.n1478 4.61534
R8660 IOVDD.n1478 IOVDD.n1477 4.61534
R8661 IOVDD.n1477 IOVDD.n1476 4.61534
R8662 IOVDD.n1476 IOVDD.n1475 4.61534
R8663 IOVDD.n1486 IOVDD.n1485 4.61534
R8664 IOVDD.n1485 IOVDD.n1484 4.61534
R8665 IOVDD.n1484 IOVDD.n1483 4.61534
R8666 IOVDD.n1483 IOVDD.n1482 4.61534
R8667 IOVDD.n1482 IOVDD.n1481 4.61534
R8668 IOVDD.n1493 IOVDD.n1492 4.61534
R8669 IOVDD.n1492 IOVDD.n1491 4.61534
R8670 IOVDD.n1491 IOVDD.n1490 4.61534
R8671 IOVDD.n1490 IOVDD.n1489 4.61534
R8672 IOVDD.n1489 IOVDD.n1488 4.61534
R8673 IOVDD.n1579 IOVDD.n1578 4.461
R8674 IOVDD.n535 IOVDD.n533 4.25119
R8675 IOVDD.n1571 IOVDD.t57 4.25113
R8676 IOVDD.n1548 IOVDD.n959 4.251
R8677 IOVDD.n951 IOVDD.n898 4.251
R8678 IOVDD.t50 IOVDD.n310 4.251
R8679 IOVDD.t50 IOVDD.n313 4.251
R8680 IOVDD.t50 IOVDD.n309 4.251
R8681 IOVDD.t50 IOVDD.n308 4.251
R8682 IOVDD.t50 IOVDD.n307 4.251
R8683 IOVDD.n1552 IOVDD.n950 4.2505
R8684 IOVDD.n1576 IOVDD.t57 4.2505
R8685 IOVDD.n792 IOVDD.t17 4.2505
R8686 IOVDD.n759 IOVDD.t33 4.2505
R8687 IOVDD.n757 IOVDD.t156 4.2505
R8688 IOVDD.n749 IOVDD.t130 4.2505
R8689 IOVDD.n783 IOVDD.n363 4.2505
R8690 IOVDD.n783 IOVDD.n364 4.2505
R8691 IOVDD.n783 IOVDD.n366 4.2505
R8692 IOVDD.n783 IOVDD.t4 4.2505
R8693 IOVDD.n783 IOVDD.n367 4.2505
R8694 IOVDD.n783 IOVDD.n368 4.2505
R8695 IOVDD.n783 IOVDD.n369 4.2505
R8696 IOVDD.n783 IOVDD.t24 4.2505
R8697 IOVDD.n783 IOVDD.t0 4.2505
R8698 IOVDD.n783 IOVDD.n370 4.2505
R8699 IOVDD.n783 IOVDD.t22 4.2505
R8700 IOVDD.n783 IOVDD.n371 4.2505
R8701 IOVDD.n783 IOVDD.n372 4.2505
R8702 IOVDD.n783 IOVDD.n373 4.2505
R8703 IOVDD.n1567 IOVDD.n867 4.24691
R8704 IOVDD.n1553 IOVDD.n948 4.24678
R8705 IOVDD.n1553 IOVDD.n920 4.24678
R8706 IOVDD.n1546 IOVDD.n901 4.24636
R8707 IOVDD.n1532 IOVDD.n901 4.24636
R8708 IOVDD.n1677 IOVDD.n64 4.24473
R8709 IOVDD.n1677 IOVDD.n126 4.2446
R8710 IOVDD.n768 IOVDD.n535 4.23234
R8711 IOVDD.n1522 IOVDD.n901 4.18355
R8712 IOVDD.n1673 IOVDD.n129 4.17416
R8713 IOVDD.n1541 IOVDD.n1509 3.75205
R8714 IOVDD.n832 IOVDD.n830 3.75205
R8715 IOVDD.n687 IOVDD.n686 3.75205
R8716 IOVDD.n1541 IOVDD.n1510 3.75119
R8717 IOVDD.n519 IOVDD.n518 3.751
R8718 IOVDD.n830 IOVDD.n829 3.75092
R8719 IOVDD.n545 IOVDD.n544 3.75092
R8720 IOVDD.n1301 IOVDD.t97 3.7505
R8721 IOVDD.t97 IOVDD.n1300 3.7505
R8722 IOVDD.t97 IOVDD.n1299 3.7505
R8723 IOVDD.t53 IOVDD.n1361 3.7505
R8724 IOVDD.t53 IOVDD.n1362 3.7505
R8725 IOVDD.n1363 IOVDD.t53 3.7505
R8726 IOVDD.t36 IOVDD.n1415 3.7505
R8727 IOVDD.t36 IOVDD.n1026 3.7505
R8728 IOVDD.t36 IOVDD.n966 3.7505
R8729 IOVDD.n1416 IOVDD.t36 3.7505
R8730 IOVDD.t87 IOVDD.n1402 3.7505
R8731 IOVDD.t87 IOVDD.n1090 3.7505
R8732 IOVDD.t87 IOVDD.n1089 3.7505
R8733 IOVDD.n1403 IOVDD.t87 3.7505
R8734 IOVDD.n1670 IOVDD.n1669 3.60991
R8735 IOVDD.n1524 IOVDD.n1523 3.401
R8736 IOVDD.n783 IOVDD.t31 3.4005
R8737 IOVDD.n781 IOVDD.n504 3.39986
R8738 IOVDD.n1677 IOVDD.n0 3.37594
R8739 IOVDD.n1677 IOVDD.n128 3.37594
R8740 IOVDD.n901 IOVDD.n841 3.32244
R8741 IOVDD.n1672 IOVDD.n129 3.3033
R8742 IOVDD.n1405 IOVDD.n964 3.163
R8743 IOVDD.n1405 IOVDD.n1404 3.163
R8744 IOVDD.n1487 IOVDD.n1480 3.08837
R8745 IOVDD.n1537 IOVDD.n1511 3.00304
R8746 IOVDD.n436 IOVDD.n433 3.00252
R8747 IOVDD.n835 IOVDD.n834 3.00177
R8748 IOVDD.n1543 IOVDD.n1509 3.00131
R8749 IOVDD.n832 IOVDD.n831 3.00131
R8750 IOVDD.n686 IOVDD.n685 3.00131
R8751 IOVDD.n850 IOVDD.t179 2.83564
R8752 IOVDD.n850 IOVDD.t181 2.83544
R8753 IOVDD.n783 IOVDD.t13 2.83383
R8754 IOVDD.n792 IOVDD.n495 2.83222
R8755 IOVDD.n1677 IOVDD.n3 2.80338
R8756 IOVDD.n1406 IOVDD.n1405 2.55026
R8757 IOVDD.n1513 IOVDD.n901 2.54224
R8758 IOVDD.n679 IOVDD.n678 2.50302
R8759 IOVDD.n434 IOVDD.n432 2.50241
R8760 IOVDD.n834 IOVDD.n833 2.50241
R8761 IOVDD.n1535 IOVDD.n1511 2.50153
R8762 IOVDD.n434 IOVDD.n433 2.50138
R8763 IOVDD.n609 IOVDD.n536 2.42957
R8764 IOVDD.n792 IOVDD.t33 2.42907
R8765 IOVDD.n1398 IOVDD.n1085 2.36483
R8766 IOVDD.n1530 IOVDD.n901 2.29267
R8767 IOVDD.n1393 IOVDD.n1238 2.21734
R8768 IOVDD.n1405 IOVDD.t11 2.18681
R8769 IOVDD.n1671 IOVDD.n1670 2.17575
R8770 IOVDD.n1669 IOVDD.n1668 2.17028
R8771 IOVDD.n685 IOVDD.n684 2.14618
R8772 IOVDD.n679 IOVDD.n676 2.14451
R8773 IOVDD.n436 IOVDD.n432 2.14443
R8774 IOVDD.n769 IOVDD.t5 2.14366
R8775 IOVDD.n771 IOVDD.t23 2.14366
R8776 IOVDD.n1567 IOVDD.n896 2.12619
R8777 IOVDD.n783 IOVDD.t17 2.1255
R8778 IOVDD.n1487 IOVDD.n1486 2.05712
R8779 IOVDD.n1494 IOVDD.n1493 2.05712
R8780 IOVDD.n1408 IOVDD.n1407 1.98983
R8781 IOVDD.t50 IOVDD.n311 1.88986
R8782 IOVDD.n1576 IOVDD.n838 1.88403
R8783 IOVDD.n687 IOVDD.n684 1.87698
R8784 IOVDD.n779 IOVDD.t114 1.86881
R8785 IOVDD.n1501 IOVDD.n1500 1.847
R8786 IOVDD.n1568 IOVDD.n1567 1.7264
R8787 IOVDD.n772 IOVDD.n535 1.71734
R8788 IOVDD.n1398 IOVDD.n1084 1.60933
R8789 IOVDD.n1677 IOVDD.n66 1.5467
R8790 IOVDD.n962 IOVDD.n961 1.52586
R8791 IOVDD.n1516 IOVDD.n901 1.51542
R8792 IOVDD.n1411 IOVDD.n962 1.4466
R8793 IOVDD.n1579 IOVDD 1.35533
R8794 IOVDD.n1528 IOVDD.n901 1.34936
R8795 IOVDD.n1553 IOVDD.t43 1.30819
R8796 IOVDD.n1645 IOVDD.n1643 1.29465
R8797 IOVDD.n1632 IOVDD.n255 1.29465
R8798 IOVDD.n1583 IOVDD.n1582 1.29465
R8799 IOVDD.n1626 IOVDD.n1625 1.29461
R8800 IOVDD.n1611 IOVDD.n1610 1.29461
R8801 IOVDD.n1601 IOVDD.n1600 1.28889
R8802 IOVDD.n1582 IOVDD.n1579 1.28827
R8803 IOVDD.n1609 IOVDD.n267 1.28621
R8804 IOVDD.n1606 IOVDD.n1605 1.28621
R8805 IOVDD.n264 IOVDD.n263 1.28621
R8806 IOVDD.n1615 IOVDD.n1614 1.28621
R8807 IOVDD.n261 IOVDD.n260 1.28621
R8808 IOVDD.n1621 IOVDD.n1620 1.28621
R8809 IOVDD.n1623 IOVDD.n259 1.28621
R8810 IOVDD.n1624 IOVDD.n257 1.28621
R8811 IOVDD.n1581 IOVDD.n1580 1.28621
R8812 IOVDD.n813 IOVDD.n812 1.28621
R8813 IOVDD.n1588 IOVDD.n1587 1.28621
R8814 IOVDD.n1589 IOVDD.n811 1.28621
R8815 IOVDD.n1591 IOVDD.n1590 1.28621
R8816 IOVDD.n807 IOVDD.n806 1.28621
R8817 IOVDD.n1598 IOVDD.n1597 1.28621
R8818 IOVDD.n1599 IOVDD.n270 1.28621
R8819 IOVDD.n1581 IOVDD.n815 1.28621
R8820 IOVDD.n814 IOVDD.n813 1.28621
R8821 IOVDD.n1587 IOVDD.n1586 1.28621
R8822 IOVDD.n811 IOVDD.n810 1.28621
R8823 IOVDD.n1592 IOVDD.n1591 1.28621
R8824 IOVDD.n808 IOVDD.n807 1.28621
R8825 IOVDD.n1597 IOVDD.n1596 1.28621
R8826 IOVDD.n270 IOVDD.n269 1.28621
R8827 IOVDD.n1602 IOVDD.n1601 1.28621
R8828 IOVDD.n1642 IOVDD.n1640 1.28621
R8829 IOVDD.n249 IOVDD.n247 1.28621
R8830 IOVDD.n1653 IOVDD.n1652 1.28621
R8831 IOVDD.n248 IOVDD.n246 1.28621
R8832 IOVDD.n1635 IOVDD.n1634 1.28621
R8833 IOVDD.n1633 IOVDD.n254 1.28621
R8834 IOVDD.n1646 IOVDD.n1641 1.28621
R8835 IOVDD.n1647 IOVDD.n1640 1.28621
R8836 IOVDD.n251 IOVDD.n249 1.28621
R8837 IOVDD.n1652 IOVDD.n1651 1.28621
R8838 IOVDD.n250 IOVDD.n248 1.28621
R8839 IOVDD.n1636 IOVDD.n1635 1.28621
R8840 IOVDD.n254 IOVDD.n253 1.28621
R8841 IOVDD.n1631 IOVDD.n1630 1.28621
R8842 IOVDD.n1645 IOVDD.n1644 1.28621
R8843 IOVDD.n1646 IOVDD.n1639 1.28621
R8844 IOVDD.n1648 IOVDD.n1647 1.28621
R8845 IOVDD.n1649 IOVDD.n251 1.28621
R8846 IOVDD.n1651 IOVDD.n1650 1.28621
R8847 IOVDD.n1638 IOVDD.n250 1.28621
R8848 IOVDD.n1637 IOVDD.n1636 1.28621
R8849 IOVDD.n253 IOVDD.n252 1.28621
R8850 IOVDD.n1630 IOVDD.n1629 1.28621
R8851 IOVDD.n1628 IOVDD.n255 1.28621
R8852 IOVDD.n1584 IOVDD.n814 1.28621
R8853 IOVDD.n1586 IOVDD.n1585 1.28621
R8854 IOVDD.n810 IOVDD.n809 1.28621
R8855 IOVDD.n1593 IOVDD.n1592 1.28621
R8856 IOVDD.n1594 IOVDD.n808 1.28621
R8857 IOVDD.n1596 IOVDD.n1595 1.28621
R8858 IOVDD.n269 IOVDD.n268 1.28621
R8859 IOVDD.n1603 IOVDD.n1602 1.28621
R8860 IOVDD.n1610 IOVDD.n1604 1.28621
R8861 IOVDD.n1609 IOVDD.n1608 1.28621
R8862 IOVDD.n1607 IOVDD.n1606 1.28621
R8863 IOVDD.n263 IOVDD.n262 1.28621
R8864 IOVDD.n1616 IOVDD.n1615 1.28621
R8865 IOVDD.n1617 IOVDD.n261 1.28621
R8866 IOVDD.n1620 IOVDD.n1619 1.28621
R8867 IOVDD.n1618 IOVDD.n259 1.28621
R8868 IOVDD.n257 IOVDD.n256 1.28621
R8869 IOVDD.n1627 IOVDD.n1626 1.28621
R8870 IOVDD.n770 IOVDD.n535 1.24365
R8871 IOVDD.n1576 IOVDD.t43 1.21479
R8872 IOVDD.n1576 IOVDD.n816 1.19982
R8873 IOVDD.n1506 IOVDD.n962 1.19452
R8874 IOVDD.n1668 IOVDD.n1667 1.17618
R8875 IOVDD.n805 IOVDD.n271 1.13487
R8876 IOVDD.n1567 IOVDD.t43 1.13383
R8877 IOVDD.n901 IOVDD.t43 1.13383
R8878 IOVDD.n1398 IOVDD.n1268 1.05869
R8879 IOVDD.n1398 IOVDD.n1397 1.05869
R8880 IOVDD.n1628 IOVDD.n1627 1.04917
R8881 IOVDD.n1501 IOVDD.n1494 1.04175
R8882 IOVDD.n1494 IOVDD.n1487 1.03175
R8883 IOVDD.t50 IOVDD.n794 1.001
R8884 IOVDD.n1086 IOVDD.n962 0.976028
R8885 IOVDD.n1576 IOVDD.n820 0.970439
R8886 IOVDD.n900 IOVDD.t126 0.945444
R8887 IOVDD.n1576 IOVDD.t126 0.944944
R8888 IOVDD IOVDD.n1505 0.943385
R8889 IOVDD.n1577 IOVDD.n1576 0.941998
R8890 IOVDD.n1409 IOVDD.n962 0.908757
R8891 IOVDD.n1567 IOVDD.n844 0.892902
R8892 IOVDD.n1553 IOVDD.n949 0.875643
R8893 IOVDD.n1668 IOVDD.n196 0.853061
R8894 IOVDD.n764 IOVDD.n537 0.851083
R8895 IOVDD.n1671 IOVDD.n136 0.851038
R8896 IOVDD.n677 IOVDD.n358 0.845663
R8897 IOVDD.n1548 IOVDD.n820 0.802107
R8898 IOVDD.n1669 IOVDD.t9 0.786253
R8899 IOVDD.n1670 IOVDD.t15 0.786253
R8900 IOVDD.n1506 IOVDD 0.780655
R8901 IOVDD.n1667 IOVDD.n1666 0.76847
R8902 IOVDD.n1567 IOVDD.n897 0.716904
R8903 IOVDD.n24 IOVDD.n4 0.712167
R8904 IOVDD IOVDD.n816 0.707043
R8905 IOVDD.n86 IOVDD.n4 0.694936
R8906 IOVDD.n1600 IOVDD.n805 0.694337
R8907 IOVDD.n1517 IOVDD.n820 0.682375
R8908 IOVDD.n1552 IOVDD.n901 0.6805
R8909 IOVDD.n1643 IOVDD.n1642 0.658904
R8910 IOVDD.n1633 IOVDD.n1632 0.658867
R8911 IOVDD.n1584 IOVDD.n1583 0.657492
R8912 IOVDD.n1507 IOVDD.n1506 0.655971
R8913 IOVDD.n1565 IOVDD.n1562 0.653273
R8914 IOVDD.n1625 IOVDD.n258 0.64058
R8915 IOVDD.n1612 IOVDD.n1611 0.640426
R8916 IOVDD.n1612 IOVDD.n265 0.639912
R8917 IOVDD.n1613 IOVDD.n1612 0.639912
R8918 IOVDD.n1622 IOVDD.n258 0.639912
R8919 IOVDD.n783 IOVDD.n511 0.638168
R8920 IOVDD.n435 IOVDD.t89 0.625349
R8921 IOVDD.n1567 IOVDD.n1565 0.625208
R8922 IOVDD.n1561 IOVDD.n897 0.624986
R8923 IOVDD.n1517 IOVDD 0.596333
R8924 IOVDD.n1578 IOVDD.n816 0.594747
R8925 IOVDD.n1529 IOVDD.n1528 0.590619
R8926 IOVDD.n1516 IOVDD.n843 0.589101
R8927 IOVDD.n788 IOVDD.n496 0.587207
R8928 IOVDD.n1330 IOVDD.n1329 0.578104
R8929 IOVDD.n136 IOVDD.n129 0.577072
R8930 IOVDD.n196 IOVDD.n129 0.576047
R8931 IOVDD.n1350 IOVDD.n1330 0.569398
R8932 IOVDD IOVDD.n510 0.568314
R8933 IOVDD.n778 IOVDD.n773 0.550063
R8934 IOVDD.n675 IOVDD.t85 0.547916
R8935 IOVDD.n677 IOVDD.t66 0.547916
R8936 IOVDD.n510 IOVDD.n509 0.540389
R8937 IOVDD.n670 IOVDD.n359 0.533734
R8938 IOVDD.n1575 IOVDD.n839 0.533202
R8939 IOVDD.n1553 IOVDD.n1552 0.515652
R8940 IOVDD.n1604 IOVDD.n1603 0.509287
R8941 IOVDD.n773 IOVDD.n772 0.5036
R8942 IOVDD.n1568 IOVDD.n853 0.491707
R8943 IOVDD.n1521 IOVDD.n1516 0.48596
R8944 IOVDD.n1528 IOVDD.n1527 0.480213
R8945 IOVDD.n779 IOVDD.n778 0.479355
R8946 IOVDD.n772 IOVDD.n771 0.478002
R8947 IOVDD.n764 IOVDD.n746 0.472106
R8948 IOVDD.n1530 IOVDD.n1529 0.4716
R8949 IOVDD.n1667 IOVDD.n129 0.470599
R8950 IOVDD.n1505 IOVDD.n962 0.469881
R8951 IOVDD.n1567 IOVDD.n839 0.460417
R8952 IOVDD.n1567 IOVDD.n1566 0.436857
R8953 IOVDD.n1672 IOVDD.n1671 0.425147
R8954 IOVDD.n1569 IOVDD.n1568 0.38698
R8955 IOVDD.n1531 IOVDD.n1530 0.370292
R8956 IOVDD.n761 IOVDD.n511 0.336065
R8957 IOVDD.n1505 IOVDD.n1504 0.330784
R8958 IOVDD.n1 IOVDD 0.328628
R8959 IOVDD.n1526 IOVDD.n949 0.326075
R8960 IOVDD.n511 IOVDD 0.317184
R8961 IOVDD.n415 IOVDD.n358 0.303189
R8962 IOVDD.n1396 IOVDD.n1084 0.301457
R8963 IOVDD.n1408 IOVDD.n1086 0.297766
R8964 IOVDD IOVDD.n1672 0.29497
R8965 IOVDD.n1504 IOVDD 0.293833
R8966 IOVDD.n1408 IOVDD.n1084 0.290878
R8967 IOVDD.n163 IOVDD.n136 0.278719
R8968 IOVDD.n196 IOVDD.n195 0.27695
R8969 IOVDD.n1409 IOVDD.n1408 0.276163
R8970 IOVDD.n1507 IOVDD.n961 0.275524
R8971 IOVDD.n1410 IOVDD.n1409 0.27476
R8972 IOVDD.n1644 IOVDD 0.272567
R8973 IOVDD.n1673 IOVDD 0.263728
R8974 IOVDD.n1395 IOVDD.n1086 0.256202
R8975 IOVDD.n1674 IOVDD.n1673 0.252728
R8976 IOVDD.n1531 IOVDD.n1513 0.233849
R8977 IOVDD.n1527 IOVDD.n1522 0.23107
R8978 IOVDD.n1655 IOVDD.n1654 0.229862
R8979 IOVDD.n1526 IOVDD.n1525 0.229586
R8980 IOVDD IOVDD.n1085 0.216304
R8981 IOVDD.n770 IOVDD.n769 0.216121
R8982 IOVDD.n851 IOVDD.n850 0.215465
R8983 IOVDD.n1408 IOVDD.n1085 0.209138
R8984 IOVDD.n771 IOVDD.n770 0.208668
R8985 IOVDD.n1519 IOVDD.n1518 0.199875
R8986 IOVDD.n1520 IOVDD.n1519 0.199875
R8987 IOVDD.n1573 IOVDD.n841 0.197434
R8988 IOVDD.n783 IOVDD.n510 0.194594
R8989 IOVDD.n843 IOVDD.n841 0.177436
R8990 IOVDD.n1521 IOVDD.n1520 0.175813
R8991 IOVDD.n1570 IOVDD.n843 0.169071
R8992 IOVDD.n1677 IOVDD.n4 0.1662
R8993 IOVDD.n1527 IOVDD.n1526 0.161186
R8994 IOVDD.n853 IOVDD.n852 0.158911
R8995 IOVDD.n1518 IOVDD 0.156333
R8996 IOVDD.n675 IOVDD.n512 0.155988
R8997 IOVDD.n821 IOVDD 0.154064
R8998 IOVDD.n1525 IOVDD.n853 0.151092
R8999 IOVDD.n1522 IOVDD.n1521 0.148886
R9000 IOVDD.n676 IOVDD.n675 0.143461
R9001 IOVDD.n1407 IOVDD.t16 0.142895
R9002 IOVDD.n1406 IOVDD.t10 0.142147
R9003 IOVDD.n1654 IOVDD.n128 0.140612
R9004 IOVDD.n678 IOVDD.n677 0.137136
R9005 IOVDD.n1500 IOVDD.t205 0.13273
R9006 IOVDD.n1499 IOVDD.t212 0.13273
R9007 IOVDD.n1498 IOVDD.t208 0.13273
R9008 IOVDD.n1497 IOVDD.t206 0.13273
R9009 IOVDD.n1496 IOVDD.t193 0.13273
R9010 IOVDD.n1495 IOVDD.t215 0.13273
R9011 IOVDD.n1480 IOVDD.t207 0.13273
R9012 IOVDD.n1479 IOVDD.t196 0.13273
R9013 IOVDD.n1478 IOVDD.t214 0.13273
R9014 IOVDD.n1477 IOVDD.t209 0.13273
R9015 IOVDD.n1476 IOVDD.t197 0.13273
R9016 IOVDD.n1475 IOVDD.t189 0.13273
R9017 IOVDD.n1486 IOVDD.t199 0.13273
R9018 IOVDD.n1485 IOVDD.t211 0.13273
R9019 IOVDD.n1484 IOVDD.t204 0.13273
R9020 IOVDD.n1483 IOVDD.t201 0.13273
R9021 IOVDD.n1482 IOVDD.t198 0.13273
R9022 IOVDD.n1481 IOVDD.t190 0.13273
R9023 IOVDD.n1493 IOVDD.t200 0.13273
R9024 IOVDD.n1492 IOVDD.t210 0.13273
R9025 IOVDD.n1491 IOVDD.t203 0.13273
R9026 IOVDD.n1490 IOVDD.t202 0.13273
R9027 IOVDD.n1489 IOVDD.t192 0.13273
R9028 IOVDD.n1488 IOVDD.t195 0.13273
R9029 IOVDD.n904 IOVDD.n897 0.123729
R9030 IOVDD.n537 IOVDD.n266 0.122053
R9031 IOVDD.n1677 IOVDD.t1 0.121929
R9032 IOVDD.n1565 IOVDD.n1564 0.119488
R9033 IOVDD.t50 IOVDD.n793 0.119056
R9034 IOVDD.t1 IOVDD.n129 0.116938
R9035 IOVDD.n3 IOVDD 0.112476
R9036 IOVDD.n1411 IOVDD.n1410 0.109125
R9037 IOVDD.n3 IOVDD.n1 0.104474
R9038 IOVDD.n1378 IOVDD.n1083 0.103857
R9039 IOVDD.t3 IOVDD.n1398 0.10169
R9040 IOVDD.n764 IOVDD.n747 0.101592
R9041 IOVDD.n1515 IOVDD.n1513 0.0964186
R9042 IOVDD.n128 IOVDD.n127 0.09595
R9043 IOVDD.n1398 IOVDD.n1330 0.0921674
R9044 IOVDD.n1517 IOVDD.n821 0.091591
R9045 IOVDD.n1508 IOVDD.n1507 0.0858731
R9046 IOVDD.n536 IOVDD.n266 0.081823
R9047 IOVDD.n768 IOVDD 0.0762523
R9048 IOVDD.n1573 IOVDD.n1570 0.0744372
R9049 IOVDD.n1529 IOVDD.n1515 0.0743931
R9050 IOVDD IOVDD.n0 0.0734819
R9051 IOVDD.n1378 IOVDD 0.0730591
R9052 IOVDD.n780 IOVDD.n779 0.0707163
R9053 IOVDD.n1395 IOVDD.n1394 0.0689925
R9054 IOVDD.n127 IOVDD.n0 0.0675909
R9055 IOVDD.n1399 IOVDD.t3 0.0566448
R9056 IOVDD.n65 IOVDD.n2 0.055905
R9057 IOVDD.n1394 IOVDD.n1393 0.0540499
R9058 IOVDD.n769 IOVDD.n768 0.0525536
R9059 IOVDD.n1577 IOVDD.n817 0.0394934
R9060 IOVDD IOVDD.n2 0.0363785
R9061 IOVDD.n1282 IOVDD.n1268 0.0363133
R9062 IOVDD.n1397 IOVDD.n1392 0.0363133
R9063 IOVDD.n767 IOVDD.n766 0.0326615
R9064 IOVDD IOVDD.n767 0.0323266
R9065 IOVDD.n805 IOVDD.n804 0.030833
R9066 IOVDD.n848 IOVDD.n846 0.0306937
R9067 IOVDD.n849 IOVDD.n847 0.0306937
R9068 IOVDD.n846 IOVDD.n845 0.0306937
R9069 IOVDD.n848 IOVDD.n847 0.0306937
R9070 IOVDD.n838 IOVDD.n837 0.0290361
R9071 IOVDD.n266 IOVDD.n258 0.0284205
R9072 IOVDD.n888 IOVDD.n844 0.0278122
R9073 IOVDD.n65 IOVDD 0.0271809
R9074 IOVDD.n961 IOVDD.n960 0.0259293
R9075 IOVDD IOVDD.n1678 0.0253085
R9076 IOVDD.n1412 IOVDD.n1411 0.024035
R9077 IOVDD.n1514 IOVDD.n949 0.023273
R9078 IOVDD.n127 IOVDD.n126 0.0230792
R9079 IOVDD IOVDD.n64 0.0229536
R9080 IOVDD.n1656 IOVDD.n1655 0.0227138
R9081 IOVDD.n1559 IOVDD.n1556 0.0221239
R9082 IOVDD.n1558 IOVDD.n1557 0.0221239
R9083 IOVDD.n766 IOVDD.n536 0.0206167
R9084 IOVDD.n64 IOVDD.n63 0.0192868
R9085 IOVDD.n126 IOVDD.n125 0.0191614
R9086 IOVDD.n1514 IOVDD.n948 0.0188697
R9087 IOVDD.n746 IOVDD.n745 0.0187524
R9088 IOVDD.n1560 IOVDD.n1554 0.0183632
R9089 IOVDD.n1559 IOVDD.n1555 0.0183632
R9090 IOVDD.n1612 IOVDD.n266 0.0182626
R9091 IOVDD.n867 IOVDD.n866 0.0178036
R9092 IOVDD IOVDD.n1517 0.0176875
R9093 IOVDD.n920 IOVDD.n919 0.0176784
R9094 IOVDD.n1532 IOVDD.n1531 0.0172991
R9095 IOVDD.n1122 IOVDD.n1093 0.017159
R9096 IOVDD.n928 IOVDD.n920 0.0168842
R9097 IOVDD.n1533 IOVDD.n1532 0.0168617
R9098 IOVDD.n876 IOVDD.n867 0.0167587
R9099 IOVDD.n1547 IOVDD.n1546 0.0167524
R9100 IOVDD.n1546 IOVDD.n1545 0.0164244
R9101 IOVDD.n1610 IOVDD.n1609 0.0163797
R9102 IOVDD.n1609 IOVDD.n1606 0.0163797
R9103 IOVDD.n1606 IOVDD.n263 0.0163797
R9104 IOVDD.n1615 IOVDD.n263 0.0163797
R9105 IOVDD.n1615 IOVDD.n261 0.0163797
R9106 IOVDD.n1620 IOVDD.n261 0.0163797
R9107 IOVDD.n1620 IOVDD.n259 0.0163797
R9108 IOVDD.n259 IOVDD.n257 0.0163797
R9109 IOVDD.n1626 IOVDD.n257 0.0163797
R9110 IOVDD.n1605 IOVDD.n267 0.0163797
R9111 IOVDD.n1614 IOVDD.n264 0.0163797
R9112 IOVDD.n1621 IOVDD.n260 0.0163797
R9113 IOVDD.n1624 IOVDD.n1623 0.0163797
R9114 IOVDD.n1582 IOVDD.n1581 0.0163797
R9115 IOVDD.n1581 IOVDD.n813 0.0163797
R9116 IOVDD.n1587 IOVDD.n813 0.0163797
R9117 IOVDD.n1587 IOVDD.n811 0.0163797
R9118 IOVDD.n1591 IOVDD.n811 0.0163797
R9119 IOVDD.n1591 IOVDD.n807 0.0163797
R9120 IOVDD.n1597 IOVDD.n807 0.0163797
R9121 IOVDD.n1597 IOVDD.n270 0.0163797
R9122 IOVDD.n1601 IOVDD.n270 0.0163797
R9123 IOVDD.n815 IOVDD.n814 0.0163797
R9124 IOVDD.n1586 IOVDD.n814 0.0163797
R9125 IOVDD.n1586 IOVDD.n810 0.0163797
R9126 IOVDD.n1592 IOVDD.n810 0.0163797
R9127 IOVDD.n1592 IOVDD.n808 0.0163797
R9128 IOVDD.n1596 IOVDD.n808 0.0163797
R9129 IOVDD.n1596 IOVDD.n269 0.0163797
R9130 IOVDD.n1602 IOVDD.n269 0.0163797
R9131 IOVDD.n1631 IOVDD.n254 0.0163797
R9132 IOVDD.n1635 IOVDD.n254 0.0163797
R9133 IOVDD.n1635 IOVDD.n248 0.0163797
R9134 IOVDD.n1652 IOVDD.n248 0.0163797
R9135 IOVDD.n1652 IOVDD.n249 0.0163797
R9136 IOVDD.n1640 IOVDD.n249 0.0163797
R9137 IOVDD.n1641 IOVDD.n1640 0.0163797
R9138 IOVDD.n1630 IOVDD.n255 0.0163797
R9139 IOVDD.n1630 IOVDD.n253 0.0163797
R9140 IOVDD.n1636 IOVDD.n253 0.0163797
R9141 IOVDD.n1636 IOVDD.n250 0.0163797
R9142 IOVDD.n1651 IOVDD.n250 0.0163797
R9143 IOVDD.n1651 IOVDD.n251 0.0163797
R9144 IOVDD.n1647 IOVDD.n251 0.0163797
R9145 IOVDD.n1647 IOVDD.n1646 0.0163797
R9146 IOVDD.n1646 IOVDD.n1645 0.0163797
R9147 IOVDD.n1093 IOVDD 0.0161281
R9148 IOVDD.n1658 IOVDD.n1656 0.0158451
R9149 IOVDD.n780 IOVDD.n509 0.0157778
R9150 IOVDD.n852 IOVDD.n845 0.0155968
R9151 IOVDD.n851 IOVDD.n849 0.0155968
R9152 IOVDD.n1634 IOVDD.n1633 0.0155857
R9153 IOVDD.n1634 IOVDD.n246 0.0155857
R9154 IOVDD.n1653 IOVDD.n247 0.0155857
R9155 IOVDD.n1642 IOVDD.n247 0.0155857
R9156 IOVDD.n1661 IOVDD.n1660 0.0155192
R9157 IOVDD.n788 IOVDD.n509 0.0153413
R9158 IOVDD.n193 IOVDD.n192 0.0151562
R9159 IOVDD.n1561 IOVDD.n1554 0.0146026
R9160 IOVDD.n1560 IOVDD.n1555 0.0146026
R9161 IOVDD.n1585 IOVDD.n1584 0.01458
R9162 IOVDD.n1585 IOVDD.n809 0.01458
R9163 IOVDD.n1593 IOVDD.n809 0.01458
R9164 IOVDD.n1594 IOVDD.n1593 0.01458
R9165 IOVDD.n1595 IOVDD.n1594 0.01458
R9166 IOVDD.n1595 IOVDD.n268 0.01458
R9167 IOVDD.n1603 IOVDD.n268 0.01458
R9168 IOVDD.n1608 IOVDD.n1604 0.01458
R9169 IOVDD.n1608 IOVDD.n1607 0.01458
R9170 IOVDD.n1607 IOVDD.n262 0.01458
R9171 IOVDD.n1616 IOVDD.n262 0.01458
R9172 IOVDD.n1617 IOVDD.n1616 0.01458
R9173 IOVDD.n1619 IOVDD.n1617 0.01458
R9174 IOVDD.n1619 IOVDD.n1618 0.01458
R9175 IOVDD.n1618 IOVDD.n256 0.01458
R9176 IOVDD.n1627 IOVDD.n256 0.01458
R9177 IOVDD.n1629 IOVDD.n1628 0.01458
R9178 IOVDD.n1629 IOVDD.n252 0.01458
R9179 IOVDD.n1637 IOVDD.n252 0.01458
R9180 IOVDD.n1638 IOVDD.n1637 0.01458
R9181 IOVDD.n1650 IOVDD.n1638 0.01458
R9182 IOVDD.n1650 IOVDD.n1649 0.01458
R9183 IOVDD.n1649 IOVDD.n1648 0.01458
R9184 IOVDD.n1648 IOVDD.n1639 0.01458
R9185 IOVDD.n1644 IOVDD.n1639 0.01458
R9186 IOVDD.n1580 IOVDD.n812 0.0143947
R9187 IOVDD.n1588 IOVDD.n812 0.0143947
R9188 IOVDD.n1589 IOVDD.n1588 0.0143947
R9189 IOVDD.n1590 IOVDD.n1589 0.0143947
R9190 IOVDD.n1590 IOVDD.n806 0.0143947
R9191 IOVDD.n1598 IOVDD.n806 0.0143947
R9192 IOVDD.n66 IOVDD.n65 0.0136096
R9193 IOVDD.n1299 IOVDD.n1296 0.0133442
R9194 IOVDD.n1364 IOVDD.n1363 0.0133442
R9195 IOVDD.n948 IOVDD.n947 0.0133102
R9196 IOVDD.n1580 IOVDD.n1579 0.0129474
R9197 IOVDD.n1674 IOVDD.n135 0.0128432
R9198 IOVDD.n1659 IOVDD.n222 0.0128432
R9199 IOVDD.n1665 IOVDD.n1663 0.0128432
R9200 IOVDD.n190 IOVDD.n189 0.0128432
R9201 IOVDD.n194 IOVDD.n161 0.0128432
R9202 IOVDD.n1268 IOVDD.n1083 0.0128195
R9203 IOVDD.n1397 IOVDD.n1396 0.0128195
R9204 IOVDD.n969 IOVDD.n968 0.0127357
R9205 IOVDD.n1414 IOVDD.n1413 0.0127357
R9206 IOVDD.n1179 IOVDD.n1151 0.0127357
R9207 IOVDD.n1401 IOVDD.n1092 0.0127357
R9208 IOVDD.n1600 IOVDD.n1599 0.0125132
R9209 IOVDD.n230 IOVDD.n229 0.0121172
R9210 IOVDD.n187 IOVDD.n186 0.0121172
R9211 IOVDD.n218 IOVDD.n198 0.0119356
R9212 IOVDD.n158 IOVDD.n138 0.0119356
R9213 IOVDD IOVDD.n1598 0.0116447
R9214 IOVDD.n36 IOVDD.n35 0.0115464
R9215 IOVDD.n98 IOVDD.n97 0.0115464
R9216 IOVDD.n906 IOVDD.n904 0.0114561
R9217 IOVDD.n804 IOVDD.n803 0.0114125
R9218 IOVDD.n232 IOVDD.n228 0.0113911
R9219 IOVDD.n185 IOVDD.n184 0.0113911
R9220 IOVDD.n1578 IOVDD.n1577 0.0113568
R9221 IOVDD.n220 IOVDD.n219 0.0112096
R9222 IOVDD.n160 IOVDD.n159 0.0112096
R9223 IOVDD.n1503 IOVDD.n1502 0.0109615
R9224 IOVDD.n968 IOVDD.n966 0.0109615
R9225 IOVDD.n1558 IOVDD.n1556 0.0108419
R9226 IOVDD.n1562 IOVDD.n1557 0.0108419
R9227 IOVDD IOVDD.n1503 0.010825
R9228 IOVDD.n56 IOVDD.n37 0.0107466
R9229 IOVDD.n32 IOVDD.n31 0.0107466
R9230 IOVDD.n118 IOVDD.n99 0.0107466
R9231 IOVDD.n94 IOVDD.n93 0.0107466
R9232 IOVDD.n1658 IOVDD.n1657 0.010665
R9233 IOVDD.n233 IOVDD.n231 0.010665
R9234 IOVDD.n1666 IOVDD.n197 0.010665
R9235 IOVDD.n164 IOVDD.n163 0.010665
R9236 IOVDD.n183 IOVDD.n182 0.010665
R9237 IOVDD.n195 IOVDD.n137 0.010665
R9238 IOVDD.n215 IOVDD.n199 0.0104835
R9239 IOVDD.n155 IOVDD.n139 0.0104835
R9240 IOVDD.n1573 IOVDD.n838 0.0103486
R9241 IOVDD.n544 IOVDD.n539 0.0102747
R9242 IOVDD.n57 IOVDD.n38 0.0101438
R9243 IOVDD.n119 IOVDD.n100 0.0101438
R9244 IOVDD.n18 IOVDD.n16 0.00999315
R9245 IOVDD.n80 IOVDD.n78 0.00999315
R9246 IOVDD.n205 IOVDD.n204 0.00993894
R9247 IOVDD.n145 IOVDD.n144 0.00993894
R9248 IOVDD.n1678 IOVDD.n1 0.0098617
R9249 IOVDD.n1444 IOVDD.n1443 0.0097804
R9250 IOVDD.n994 IOVDD.n993 0.0097804
R9251 IOVDD.n1051 IOVDD.n1050 0.0097804
R9252 IOVDD.n1141 IOVDD.n1109 0.0097804
R9253 IOVDD.n1191 IOVDD.n1164 0.0097804
R9254 IOVDD.n1250 IOVDD.n1222 0.0097804
R9255 IOVDD.n243 IOVDD.n223 0.00975743
R9256 IOVDD.n235 IOVDD.n227 0.00975743
R9257 IOVDD.n166 IOVDD.n165 0.00975743
R9258 IOVDD.n181 IOVDD.n180 0.00975743
R9259 IOVDD.n1316 IOVDD.n1302 0.00965511
R9260 IOVDD.n1358 IOVDD.n1357 0.00965511
R9261 IOVDD.n1442 IOVDD.n1441 0.00964392
R9262 IOVDD.n991 IOVDD.n990 0.00964392
R9263 IOVDD.n996 IOVDD.n995 0.00964392
R9264 IOVDD.n1002 IOVDD.n1001 0.00964392
R9265 IOVDD.n1049 IOVDD.n1048 0.00964392
R9266 IOVDD.n1054 IOVDD.n1053 0.00964392
R9267 IOVDD.n1130 IOVDD.n1110 0.00964392
R9268 IOVDD.n1190 IOVDD.n1162 0.00964392
R9269 IOVDD.n1192 IOVDD.n1165 0.00964392
R9270 IOVDD.n1196 IOVDD.n1167 0.00964392
R9271 IOVDD.n1249 IOVDD.n1220 0.00964392
R9272 IOVDD.n1251 IOVDD.n1223 0.00964392
R9273 IOVDD.n217 IOVDD.n216 0.00957591
R9274 IOVDD.n157 IOVDD.n156 0.00957591
R9275 IOVDD.n55 IOVDD.n39 0.0095411
R9276 IOVDD.n117 IOVDD.n101 0.0095411
R9277 IOVDD.n1410 IOVDD.n1083 0.00951639
R9278 IOVDD.n1300 IOVDD.n1298 0.00951639
R9279 IOVDD.n1302 IOVDD.n1301 0.00951639
R9280 IOVDD.n1317 IOVDD.n1304 0.00951639
R9281 IOVDD.n1396 IOVDD.n1395 0.00951639
R9282 IOVDD.n1362 IOVDD.n1359 0.00951639
R9283 IOVDD.n1361 IOVDD.n1358 0.00951639
R9284 IOVDD.n1344 IOVDD.n1342 0.00951639
R9285 IOVDD.n1447 IOVDD.n1446 0.00950744
R9286 IOVDD.n1440 IOVDD.n1439 0.00950744
R9287 IOVDD.n1004 IOVDD.n1003 0.00950744
R9288 IOVDD.n1056 IOVDD.n1055 0.00950744
R9289 IOVDD.n1129 IOVDD.n1107 0.00950744
R9290 IOVDD.n1140 IOVDD.n1111 0.00950744
R9291 IOVDD.n1197 IOVDD.n1168 0.00950744
R9292 IOVDD.n1252 IOVDD.n1224 0.00950744
R9293 IOVDD.n30 IOVDD.n15 0.00939041
R9294 IOVDD.n92 IOVDD.n77 0.00939041
R9295 IOVDD.n1449 IOVDD.n1448 0.00937097
R9296 IOVDD.n989 IOVDD.n988 0.00937097
R9297 IOVDD.n1047 IOVDD.n1046 0.00937097
R9298 IOVDD.n1142 IOVDD.n1106 0.00937097
R9299 IOVDD.n1089 IOVDD.n1088 0.00937097
R9300 IOVDD.n1189 IOVDD.n1161 0.00937097
R9301 IOVDD.n1248 IOVDD.n1219 0.00937097
R9302 IOVDD.n766 IOVDD.n537 0.009322
R9303 IOVDD.n1539 IOVDD.n1538 0.00930933
R9304 IOVDD.n826 IOVDD.n825 0.00930933
R9305 IOVDD.n1282 IOVDD.n1269 0.00923897
R9306 IOVDD.n1392 IOVDD.n1377 0.00923897
R9307 IOVDD.n1451 IOVDD.n1450 0.00923449
R9308 IOVDD.n1438 IOVDD.n1437 0.00923449
R9309 IOVDD.n987 IOVDD.n986 0.00923449
R9310 IOVDD.n1006 IOVDD.n1005 0.00923449
R9311 IOVDD.n1026 IOVDD.n1025 0.00923449
R9312 IOVDD.n1415 IOVDD.n1027 0.00923449
R9313 IOVDD.n1045 IOVDD.n1044 0.00923449
R9314 IOVDD.n1058 IOVDD.n1057 0.00923449
R9315 IOVDD.n1128 IOVDD.n1105 0.00923449
R9316 IOVDD.n1131 IOVDD.n1112 0.00923449
R9317 IOVDD.n1188 IOVDD.n1160 0.00923449
R9318 IOVDD.n1198 IOVDD.n1169 0.00923449
R9319 IOVDD.n1209 IOVDD.n1090 0.00923449
R9320 IOVDD.n1402 IOVDD.n1091 0.00923449
R9321 IOVDD.n1247 IOVDD.n1218 0.00923449
R9322 IOVDD.n1253 IOVDD.n1225 0.00923449
R9323 IOVDD.n207 IOVDD.n203 0.00921287
R9324 IOVDD.n147 IOVDD.n143 0.00921287
R9325 IOVDD.n932 IOVDD.n931 0.00914012
R9326 IOVDD.n879 IOVDD.n878 0.00914012
R9327 IOVDD.n1453 IOVDD.n1452 0.00909801
R9328 IOVDD.n1436 IOVDD.n1435 0.00909801
R9329 IOVDD.n985 IOVDD.n984 0.00909801
R9330 IOVDD.n1008 IOVDD.n1007 0.00909801
R9331 IOVDD.n1043 IOVDD.n1042 0.00909801
R9332 IOVDD.n1060 IOVDD.n1059 0.00909801
R9333 IOVDD.n1143 IOVDD.n1104 0.00909801
R9334 IOVDD.n1139 IOVDD.n1113 0.00909801
R9335 IOVDD.n1187 IOVDD.n1159 0.00909801
R9336 IOVDD.n1199 IOVDD.n1170 0.00909801
R9337 IOVDD.n1246 IOVDD.n1217 0.00909801
R9338 IOVDD.n1254 IOVDD.n1226 0.00909801
R9339 IOVDD.n245 IOVDD.n244 0.00903135
R9340 IOVDD.n236 IOVDD.n234 0.00903135
R9341 IOVDD.n168 IOVDD.n167 0.00903135
R9342 IOVDD.n179 IOVDD.n178 0.00903135
R9343 IOVDD.n1541 IOVDD.n1540 0.00898129
R9344 IOVDD.n1535 IOVDD.n1534 0.00898129
R9345 IOVDD.n831 IOVDD.n824 0.00898129
R9346 IOVDD.n836 IOVDD.n835 0.00898129
R9347 IOVDD.n1295 IOVDD.n1281 0.00896154
R9348 IOVDD.n1318 IOVDD.n1305 0.00896154
R9349 IOVDD.n1391 IOVDD.n1365 0.00896154
R9350 IOVDD.n1356 IOVDD.n1341 0.00896154
R9351 IOVDD.n1434 IOVDD.n1433 0.00896154
R9352 IOVDD.n1010 IOVDD.n1009 0.00896154
R9353 IOVDD.n1062 IOVDD.n1061 0.00896154
R9354 IOVDD.n1132 IOVDD.n1114 0.00896154
R9355 IOVDD.n1200 IOVDD.n1171 0.00896154
R9356 IOVDD.n1255 IOVDD.n1227 0.00896154
R9357 IOVDD.n495 IOVDD.n494 0.00895349
R9358 IOVDD.n63 IOVDD.n49 0.00893836
R9359 IOVDD.n58 IOVDD.n40 0.00893836
R9360 IOVDD.n24 IOVDD.n5 0.00893836
R9361 IOVDD.n125 IOVDD.n111 0.00893836
R9362 IOVDD.n120 IOVDD.n102 0.00893836
R9363 IOVDD.n86 IOVDD.n67 0.00893836
R9364 IOVDD.n1605 IOVDD.n265 0.00889112
R9365 IOVDD.n1614 IOVDD.n1613 0.00889112
R9366 IOVDD.n1622 IOVDD.n1621 0.00889112
R9367 IOVDD.n265 IOVDD.n264 0.00889112
R9368 IOVDD.n1613 IOVDD.n260 0.00889112
R9369 IOVDD.n1623 IOVDD.n1622 0.00889112
R9370 IOVDD.n1611 IOVDD.n267 0.00888484
R9371 IOVDD.n1625 IOVDD.n1624 0.00888296
R9372 IOVDD.n1545 IOVDD.n1544 0.00887195
R9373 IOVDD.n1540 IOVDD.n1539 0.00887195
R9374 IOVDD.n822 IOVDD.n817 0.00887195
R9375 IOVDD.n825 IOVDD.n824 0.00887195
R9376 IOVDD.n1662 IOVDD.n221 0.00884983
R9377 IOVDD.n212 IOVDD.n200 0.00884983
R9378 IOVDD.n191 IOVDD.n190 0.00884983
R9379 IOVDD.n192 IOVDD.n162 0.00884983
R9380 IOVDD.n152 IOVDD.n140 0.00884983
R9381 IOVDD.n1583 IOVDD.n815 0.00884841
R9382 IOVDD.n1632 IOVDD.n1631 0.0088439
R9383 IOVDD.n1643 IOVDD.n1641 0.00884346
R9384 IOVDD.n1455 IOVDD.n1454 0.00882506
R9385 IOVDD.n1432 IOVDD.n1431 0.00882506
R9386 IOVDD.n983 IOVDD.n982 0.00882506
R9387 IOVDD.n1012 IOVDD.n1011 0.00882506
R9388 IOVDD.n1041 IOVDD.n1040 0.00882506
R9389 IOVDD.n1127 IOVDD.n1103 0.00882506
R9390 IOVDD.n1138 IOVDD.n1115 0.00882506
R9391 IOVDD.n1186 IOVDD.n1158 0.00882506
R9392 IOVDD.n1201 IOVDD.n1172 0.00882506
R9393 IOVDD.n1245 IOVDD.n1216 0.00882506
R9394 IOVDD.n19 IOVDD.n14 0.00878767
R9395 IOVDD.n81 IOVDD.n76 0.00878767
R9396 IOVDD.n1457 IOVDD.n1456 0.00868858
R9397 IOVDD.n981 IOVDD.n980 0.00868858
R9398 IOVDD.n1039 IOVDD.n1038 0.00868858
R9399 IOVDD.n1064 IOVDD.n1063 0.00868858
R9400 IOVDD.n1144 IOVDD.n1102 0.00868858
R9401 IOVDD.n1185 IOVDD.n1157 0.00868858
R9402 IOVDD.n1244 IOVDD.n1215 0.00868858
R9403 IOVDD.n1256 IOVDD.n1228 0.00868858
R9404 IOVDD.n791 IOVDD.n497 0.00863928
R9405 IOVDD.n1459 IOVDD.n1458 0.00855211
R9406 IOVDD.n1430 IOVDD.n1429 0.00855211
R9407 IOVDD.n979 IOVDD.n978 0.00855211
R9408 IOVDD.n1014 IOVDD.n1013 0.00855211
R9409 IOVDD.n1037 IOVDD.n1036 0.00855211
R9410 IOVDD.n1066 IOVDD.n1065 0.00855211
R9411 IOVDD.n1126 IOVDD.n1101 0.00855211
R9412 IOVDD.n1133 IOVDD.n1116 0.00855211
R9413 IOVDD.n1184 IOVDD.n1156 0.00855211
R9414 IOVDD.n1202 IOVDD.n1173 0.00855211
R9415 IOVDD.n1243 IOVDD.n1214 0.00855211
R9416 IOVDD.n1257 IOVDD.n1229 0.00855211
R9417 IOVDD.n1283 IOVDD.n1270 0.0085454
R9418 IOVDD.n1379 IOVDD.n1376 0.0085454
R9419 IOVDD.t217 IOVDD.t219 0.00851064
R9420 IOVDD.t224 IOVDD.t218 0.00851064
R9421 IOVDD.n1663 IOVDD.n1662 0.0084868
R9422 IOVDD.n208 IOVDD.n206 0.0084868
R9423 IOVDD.n148 IOVDD.n146 0.0084868
R9424 IOVDD.n765 IOVDD.n538 0.0084644
R9425 IOVDD.n1534 IOVDD.n1533 0.00843457
R9426 IOVDD.n837 IOVDD.n836 0.00843457
R9427 IOVDD.n1428 IOVDD.n1427 0.00841563
R9428 IOVDD.n977 IOVDD.n976 0.00841563
R9429 IOVDD.n1016 IOVDD.n1015 0.00841563
R9430 IOVDD.n1035 IOVDD.n1034 0.00841563
R9431 IOVDD.n1068 IOVDD.n1067 0.00841563
R9432 IOVDD.n1137 IOVDD.n1117 0.00841563
R9433 IOVDD.n1183 IOVDD.n1155 0.00841563
R9434 IOVDD.n1203 IOVDD.n1174 0.00841563
R9435 IOVDD.n1242 IOVDD.n1213 0.00841563
R9436 IOVDD.n1258 IOVDD.n1230 0.00841563
R9437 IOVDD.n1294 IOVDD.n1280 0.00840668
R9438 IOVDD.n1319 IOVDD.n1306 0.00840668
R9439 IOVDD.n1390 IOVDD.n1366 0.00840668
R9440 IOVDD.n1345 IOVDD.n1340 0.00840668
R9441 IOVDD.n25 IOVDD.n6 0.00833562
R9442 IOVDD.n87 IOVDD.n68 0.00833562
R9443 IOVDD.n240 IOVDD.n224 0.00830528
R9444 IOVDD.n238 IOVDD.n226 0.00830528
R9445 IOVDD.n170 IOVDD.n169 0.00830528
R9446 IOVDD.n177 IOVDD.n176 0.00830528
R9447 IOVDD.n778 IOVDD.n777 0.0082802
R9448 IOVDD.n1461 IOVDD.n1460 0.00827916
R9449 IOVDD.n1426 IOVDD.n1425 0.00827916
R9450 IOVDD.n1018 IOVDD.n1017 0.00827916
R9451 IOVDD.n1070 IOVDD.n1069 0.00827916
R9452 IOVDD.n1145 IOVDD.n1100 0.00827916
R9453 IOVDD.n1134 IOVDD.n1118 0.00827916
R9454 IOVDD.n1204 IOVDD.n1175 0.00827916
R9455 IOVDD.n1259 IOVDD.n1231 0.00827916
R9456 IOVDD.n1654 IOVDD.n1653 0.0082
R9457 IOVDD.n50 IOVDD.n48 0.00818493
R9458 IOVDD.n54 IOVDD.n41 0.00818493
R9459 IOVDD.n112 IOVDD.n110 0.00818493
R9460 IOVDD.n116 IOVDD.n103 0.00818493
R9461 IOVDD.n1463 IOVDD.n1462 0.00814268
R9462 IOVDD.n975 IOVDD.n974 0.00814268
R9463 IOVDD.n1033 IOVDD.n1032 0.00814268
R9464 IOVDD.n1125 IOVDD.n1099 0.00814268
R9465 IOVDD.n1182 IOVDD.n1154 0.00814268
R9466 IOVDD.n1241 IOVDD.n1212 0.00814268
R9467 IOVDD.n1300 IOVDD.n1297 0.00812926
R9468 IOVDD.n1362 IOVDD.n1360 0.00812926
R9469 IOVDD.n214 IOVDD.n213 0.00812376
R9470 IOVDD.n154 IOVDD.n153 0.00812376
R9471 IOVDD.n1664 IOVDD.n198 0.00807697
R9472 IOVDD.n29 IOVDD.n13 0.00803425
R9473 IOVDD.n91 IOVDD.n75 0.00803425
R9474 IOVDD.n1465 IOVDD.n1464 0.0080062
R9475 IOVDD.n1424 IOVDD.n1423 0.0080062
R9476 IOVDD.n973 IOVDD.n972 0.0080062
R9477 IOVDD.n1020 IOVDD.n1019 0.0080062
R9478 IOVDD.n1031 IOVDD.n1030 0.0080062
R9479 IOVDD.n1072 IOVDD.n1071 0.0080062
R9480 IOVDD.n1146 IOVDD.n1098 0.0080062
R9481 IOVDD.n1136 IOVDD.n1119 0.0080062
R9482 IOVDD.n1181 IOVDD.n1153 0.0080062
R9483 IOVDD.n1205 IOVDD.n1176 0.0080062
R9484 IOVDD.n1240 IOVDD.n1211 0.0080062
R9485 IOVDD.n1260 IOVDD.n1232 0.0080062
R9486 IOVDD.n1284 IOVDD.n1271 0.00799054
R9487 IOVDD.n1329 IOVDD.n1315 0.00799054
R9488 IOVDD.n1380 IOVDD.n1375 0.00799054
R9489 IOVDD.n1350 IOVDD.n1331 0.00799054
R9490 IOVDD.n676 IOVDD.n674 0.00792111
R9491 IOVDD.n188 IOVDD.n187 0.00789545
R9492 IOVDD.n1544 IOVDD.n1543 0.00788786
R9493 IOVDD.n1538 IOVDD.n1537 0.00788786
R9494 IOVDD.n830 IOVDD.n822 0.00788786
R9495 IOVDD.n833 IOVDD.n826 0.00788786
R9496 IOVDD.n1654 IOVDD.n246 0.00788571
R9497 IOVDD.n1467 IOVDD.n1466 0.00786973
R9498 IOVDD.n1422 IOVDD.n1421 0.00786973
R9499 IOVDD.n971 IOVDD.n970 0.00786973
R9500 IOVDD.n1022 IOVDD.n1021 0.00786973
R9501 IOVDD.n1029 IOVDD.n1028 0.00786973
R9502 IOVDD.n1074 IOVDD.n1073 0.00786973
R9503 IOVDD.n1124 IOVDD.n1097 0.00786973
R9504 IOVDD.n1135 IOVDD.n1120 0.00786973
R9505 IOVDD.n1180 IOVDD.n1152 0.00786973
R9506 IOVDD.n1206 IOVDD.n1177 0.00786973
R9507 IOVDD.n1239 IOVDD.n1210 0.00786973
R9508 IOVDD.n1261 IOVDD.n1233 0.00786973
R9509 IOVDD.n1293 IOVDD.n1279 0.00785183
R9510 IOVDD.n1389 IOVDD.n1367 0.00785183
R9511 IOVDD.n792 IOVDD.n358 0.00776648
R9512 IOVDD.n1420 IOVDD.n1419 0.00773325
R9513 IOVDD.n1023 IOVDD.n967 0.00773325
R9514 IOVDD.n1076 IOVDD.n1075 0.00773325
R9515 IOVDD.n1150 IOVDD.n1121 0.00773325
R9516 IOVDD.n1207 IOVDD.n1178 0.00773325
R9517 IOVDD.n1262 IOVDD.n1234 0.00773325
R9518 IOVDD.n23 IOVDD.n7 0.00773288
R9519 IOVDD.n85 IOVDD.n69 0.00773288
R9520 IOVDD.n1320 IOVDD.n1307 0.00771311
R9521 IOVDD.n1355 IOVDD.n1339 0.00771311
R9522 IOVDD.n1469 IOVDD.n1468 0.00759677
R9523 IOVDD.n1418 IOVDD.n1417 0.00759677
R9524 IOVDD.n1025 IOVDD.n1024 0.00759677
R9525 IOVDD.n1147 IOVDD.n1096 0.00759677
R9526 IOVDD.n1149 IOVDD.n1087 0.00759677
R9527 IOVDD.n1209 IOVDD.n1208 0.00759677
R9528 IOVDD.n62 IOVDD.n47 0.00758219
R9529 IOVDD.n59 IOVDD.n42 0.00758219
R9530 IOVDD.n124 IOVDD.n109 0.00758219
R9531 IOVDD.n121 IOVDD.n104 0.00758219
R9532 IOVDD.n210 IOVDD.n202 0.00757921
R9533 IOVDD.n150 IOVDD.n142 0.00757921
R9534 IOVDD.n766 IOVDD.n765 0.00752056
R9535 IOVDD.n1471 IOVDD.n1470 0.0074603
R9536 IOVDD.n1078 IOVDD.n1077 0.0074603
R9537 IOVDD.n1123 IOVDD.n1095 0.0074603
R9538 IOVDD.n1263 IOVDD.n1235 0.0074603
R9539 IOVDD.n1285 IOVDD.n1272 0.00743569
R9540 IOVDD.n1328 IOVDD.n1314 0.00743569
R9541 IOVDD.n1381 IOVDD.n1374 0.00743569
R9542 IOVDD.n1351 IOVDD.n1332 0.00743569
R9543 IOVDD.n20 IOVDD.n12 0.00743151
R9544 IOVDD.n82 IOVDD.n74 0.00743151
R9545 IOVDD.n242 IOVDD.n241 0.00739769
R9546 IOVDD.n239 IOVDD.n237 0.00739769
R9547 IOVDD.n172 IOVDD.n171 0.00739769
R9548 IOVDD.n175 IOVDD.n174 0.00739769
R9549 IOVDD.n1472 IOVDD.n963 0.00732382
R9550 IOVDD.n1080 IOVDD.n1079 0.00732382
R9551 IOVDD.n1148 IOVDD.n1094 0.00732382
R9552 IOVDD.n1264 IOVDD.n1236 0.00732382
R9553 IOVDD.n1292 IOVDD.n1278 0.00729697
R9554 IOVDD.n1388 IOVDD.n1368 0.00729697
R9555 IOVDD.n209 IOVDD.n201 0.00721617
R9556 IOVDD.n149 IOVDD.n141 0.00721617
R9557 IOVDD.n800 IOVDD.n273 0.00720294
R9558 IOVDD.n353 IOVDD.n295 0.00720294
R9559 IOVDD.n1082 IOVDD.n1081 0.00718734
R9560 IOVDD.n1265 IOVDD.n1237 0.00718734
R9561 IOVDD.n1660 IOVDD.n1659 0.00716938
R9562 IOVDD.n1665 IOVDD.n1664 0.00716938
R9563 IOVDD.n189 IOVDD.n188 0.00716938
R9564 IOVDD.n194 IOVDD.n193 0.00716938
R9565 IOVDD.n1321 IOVDD.n1308 0.00715826
R9566 IOVDD.n1346 IOVDD.n1338 0.00715826
R9567 IOVDD.n26 IOVDD.n8 0.00713014
R9568 IOVDD.n88 IOVDD.n70 0.00713014
R9569 IOVDD.n352 IOVDD.n283 0.00708324
R9570 IOVDD.n518 IOVDD.n517 0.00708324
R9571 IOVDD.n514 IOVDD.n497 0.00708324
R9572 IOVDD.n1474 IOVDD.n1473 0.00705087
R9573 IOVDD.n1267 IOVDD.n1266 0.00705087
R9574 IOVDD.n51 IOVDD.n46 0.00697945
R9575 IOVDD.n53 IOVDD.n43 0.00697945
R9576 IOVDD.n113 IOVDD.n108 0.00697945
R9577 IOVDD.n115 IOVDD.n105 0.00697945
R9578 IOVDD.n799 IOVDD.n276 0.00696355
R9579 IOVDD.n349 IOVDD.n284 0.00696355
R9580 IOVDD.n788 IOVDD.n495 0.00692431
R9581 IOVDD.n1327 IOVDD.n1313 0.00688083
R9582 IOVDD.n1349 IOVDD.n1333 0.00688083
R9583 IOVDD.n18 IOVDD.n17 0.00687517
R9584 IOVDD.n80 IOVDD.n79 0.00687517
R9585 IOVDD.n211 IOVDD.n209 0.00685314
R9586 IOVDD.n151 IOVDD.n149 0.00685314
R9587 IOVDD.n798 IOVDD.n797 0.00684385
R9588 IOVDD.n348 IOVDD.n285 0.00684385
R9589 IOVDD.n28 IOVDD.n11 0.00682877
R9590 IOVDD.n90 IOVDD.n73 0.00682877
R9591 IOVDD.n936 IOVDD.n935 0.00675451
R9592 IOVDD.n934 IOVDD.n933 0.00675451
R9593 IOVDD.n883 IOVDD.n882 0.00675451
R9594 IOVDD.n881 IOVDD.n880 0.00675451
R9595 IOVDD.n1286 IOVDD.n1273 0.00674212
R9596 IOVDD.n1382 IOVDD.n1373 0.00674212
R9597 IOVDD.n304 IOVDD.n277 0.00672416
R9598 IOVDD.n1296 IOVDD.n1295 0.00668596
R9599 IOVDD.n1391 IOVDD.n1364 0.00668596
R9600 IOVDD.n241 IOVDD.n225 0.00667162
R9601 IOVDD.n237 IOVDD.n225 0.00667162
R9602 IOVDD.n173 IOVDD.n172 0.00667162
R9603 IOVDD.n174 IOVDD.n173 0.00667162
R9604 IOVDD.n518 IOVDD.n516 0.00662471
R9605 IOVDD.n345 IOVDD.n286 0.00660446
R9606 IOVDD.n1291 IOVDD.n1277 0.0066034
R9607 IOVDD.n1322 IOVDD.n1309 0.0066034
R9608 IOVDD.n1387 IOVDD.n1369 0.0066034
R9609 IOVDD.n1354 IOVDD.n1337 0.0066034
R9610 IOVDD.n34 IOVDD.n32 0.0065274
R9611 IOVDD.n96 IOVDD.n94 0.0065274
R9612 IOVDD.n516 IOVDD.n295 0.00650501
R9613 IOVDD.n211 IOVDD.n210 0.0064901
R9614 IOVDD.n151 IOVDD.n150 0.0064901
R9615 IOVDD.n305 IOVDD.n303 0.00648477
R9616 IOVDD.n344 IOVDD.n287 0.00648477
R9617 IOVDD.n907 IOVDD.n905 0.00645668
R9618 IOVDD.n1563 IOVDD.n854 0.00645668
R9619 IOVDD.n22 IOVDD.n9 0.00637671
R9620 IOVDD.n84 IOVDD.n71 0.00637671
R9621 IOVDD.n315 IOVDD.n278 0.00636507
R9622 IOVDD.n341 IOVDD.n288 0.00636507
R9623 IOVDD.n1326 IOVDD.n1312 0.00632598
R9624 IOVDD.n1352 IOVDD.n1334 0.00632598
R9625 IOVDD.n316 IOVDD.n302 0.00624538
R9626 IOVDD.n61 IOVDD.n45 0.00622603
R9627 IOVDD.n60 IOVDD.n44 0.00622603
R9628 IOVDD.n123 IOVDD.n107 0.00622603
R9629 IOVDD.n122 IOVDD.n106 0.00622603
R9630 IOVDD.n1287 IOVDD.n1274 0.00618726
R9631 IOVDD.n1383 IOVDD.n1372 0.00618726
R9632 IOVDD.n1415 IOVDD.n1414 0.00618484
R9633 IOVDD.n1402 IOVDD.n1401 0.00618484
R9634 IOVDD.n1317 IOVDD.n1303 0.0061311
R9635 IOVDD.n1344 IOVDD.n1343 0.0061311
R9636 IOVDD.n213 IOVDD.n201 0.00612706
R9637 IOVDD.n153 IOVDD.n141 0.00612706
R9638 IOVDD.n319 IOVDD.n279 0.00612568
R9639 IOVDD.n340 IOVDD.n289 0.00612568
R9640 IOVDD.n56 IOVDD.n36 0.00612174
R9641 IOVDD.n31 IOVDD.n17 0.00612174
R9642 IOVDD.n118 IOVDD.n98 0.00612174
R9643 IOVDD.n93 IOVDD.n79 0.00612174
R9644 IOVDD.n21 IOVDD.n10 0.00607534
R9645 IOVDD.n83 IOVDD.n72 0.00607534
R9646 IOVDD.n947 IOVDD.n941 0.00605957
R9647 IOVDD.n946 IOVDD.n940 0.00605957
R9648 IOVDD.n942 IOVDD.n939 0.00605957
R9649 IOVDD.n945 IOVDD.n938 0.00605957
R9650 IOVDD.n943 IOVDD.n937 0.00605957
R9651 IOVDD.n944 IOVDD.n936 0.00605957
R9652 IOVDD.n918 IOVDD.n913 0.00605957
R9653 IOVDD.n914 IOVDD.n912 0.00605957
R9654 IOVDD.n917 IOVDD.n911 0.00605957
R9655 IOVDD.n915 IOVDD.n910 0.00605957
R9656 IOVDD.n916 IOVDD.n909 0.00605957
R9657 IOVDD.n894 IOVDD.n888 0.00605957
R9658 IOVDD.n893 IOVDD.n887 0.00605957
R9659 IOVDD.n889 IOVDD.n886 0.00605957
R9660 IOVDD.n890 IOVDD.n885 0.00605957
R9661 IOVDD.n892 IOVDD.n884 0.00605957
R9662 IOVDD.n891 IOVDD.n883 0.00605957
R9663 IOVDD.n861 IOVDD.n860 0.00605957
R9664 IOVDD.n862 IOVDD.n859 0.00605957
R9665 IOVDD.n863 IOVDD.n858 0.00605957
R9666 IOVDD.n865 IOVDD.n857 0.00605957
R9667 IOVDD.n864 IOVDD.n856 0.00605957
R9668 IOVDD.n1290 IOVDD.n1276 0.00604855
R9669 IOVDD.n1386 IOVDD.n1370 0.00604855
R9670 IOVDD.n1151 IOVDD.n1089 0.00604836
R9671 IOVDD.n337 IOVDD.n290 0.00600598
R9672 IOVDD.n1316 IOVDD.n1303 0.00599239
R9673 IOVDD.n1357 IOVDD.n1343 0.00599239
R9674 IOVDD.n242 IOVDD.n240 0.00594554
R9675 IOVDD.n239 IOVDD.n238 0.00594554
R9676 IOVDD.n171 IOVDD.n170 0.00594554
R9677 IOVDD.n176 IOVDD.n175 0.00594554
R9678 IOVDD.n34 IOVDD.n33 0.00592466
R9679 IOVDD.n96 IOVDD.n95 0.00592466
R9680 IOVDD.n1446 IOVDD.n1445 0.00591189
R9681 IOVDD.n1129 IOVDD.n1108 0.00591189
R9682 IOVDD.n1323 IOVDD.n1310 0.00590984
R9683 IOVDD.n1347 IOVDD.n1336 0.00590984
R9684 IOVDD.n320 IOVDD.n301 0.00588629
R9685 IOVDD.n336 IOVDD.n291 0.00588629
R9686 IOVDD.n992 IOVDD.n991 0.00577541
R9687 IOVDD.n1001 IOVDD.n1000 0.00577541
R9688 IOVDD.n1053 IOVDD.n1052 0.00577541
R9689 IOVDD.n1190 IOVDD.n1163 0.00577541
R9690 IOVDD.n1196 IOVDD.n1166 0.00577541
R9691 IOVDD.n1249 IOVDD.n1221 0.00577541
R9692 IOVDD.n998 IOVDD.n997 0.00577533
R9693 IOVDD.n999 IOVDD.n998 0.00577533
R9694 IOVDD.n1195 IOVDD.n1194 0.00577533
R9695 IOVDD.n1194 IOVDD.n1193 0.00577533
R9696 IOVDD.n27 IOVDD.n10 0.00577397
R9697 IOVDD.n89 IOVDD.n72 0.00577397
R9698 IOVDD.n323 IOVDD.n280 0.00576659
R9699 IOVDD.n333 IOVDD.n292 0.00576659
R9700 IOVDD.n206 IOVDD.n202 0.00576403
R9701 IOVDD.n146 IOVDD.n142 0.00576403
R9702 IOVDD.n965 IOVDD.n964 0.0056861
R9703 IOVDD.n324 IOVDD.n300 0.0056469
R9704 IOVDD.n1000 IOVDD.n999 0.00563893
R9705 IOVDD.n1052 IOVDD.n1051 0.00563893
R9706 IOVDD.n993 IOVDD.n992 0.00563893
R9707 IOVDD.n1445 IOVDD.n1444 0.00563893
R9708 IOVDD.n1195 IOVDD.n1166 0.00563893
R9709 IOVDD.n1141 IOVDD.n1108 0.00563893
R9710 IOVDD.n1191 IOVDD.n1163 0.00563893
R9711 IOVDD.n1250 IOVDD.n1221 0.00563893
R9712 IOVDD.n1288 IOVDD.n1275 0.00563241
R9713 IOVDD.n1325 IOVDD.n1311 0.00563241
R9714 IOVDD.n1384 IOVDD.n1371 0.00563241
R9715 IOVDD.n1348 IOVDD.n1335 0.00563241
R9716 IOVDD.n52 IOVDD.n45 0.00562329
R9717 IOVDD.n52 IOVDD.n44 0.00562329
R9718 IOVDD.n114 IOVDD.n107 0.00562329
R9719 IOVDD.n114 IOVDD.n106 0.00562329
R9720 IOVDD.n916 IOVDD.n908 0.00556612
R9721 IOVDD.n864 IOVDD.n855 0.00556612
R9722 IOVDD.n332 IOVDD.n293 0.0055272
R9723 IOVDD.n1289 IOVDD.n1275 0.00549369
R9724 IOVDD.n1385 IOVDD.n1371 0.00549369
R9725 IOVDD.n27 IOVDD.n9 0.0054726
R9726 IOVDD.n89 IOVDD.n71 0.0054726
R9727 IOVDD.n327 IOVDD.n281 0.00540751
R9728 IOVDD.n776 IOVDD.n294 0.00540751
R9729 IOVDD.n791 IOVDD.n504 0.00538882
R9730 IOVDD.n1324 IOVDD.n1311 0.00535498
R9731 IOVDD.n1353 IOVDD.n1335 0.00535498
R9732 IOVDD.n35 IOVDD.n33 0.00532192
R9733 IOVDD.n97 IOVDD.n95 0.00532192
R9734 IOVDD.n1569 IOVDD.n844 0.00530598
R9735 IOVDD.n604 IOVDD.n574 0.00530499
R9736 IOVDD.n590 IOVDD.n548 0.00530499
R9737 IOVDD.n328 IOVDD.n299 0.00528781
R9738 IOVDD.n1404 IOVDD.n1403 0.00527667
R9739 IOVDD.n930 IOVDD.n925 0.00526534
R9740 IOVDD.n926 IOVDD.n924 0.00526534
R9741 IOVDD.n929 IOVDD.n923 0.00526534
R9742 IOVDD.n929 IOVDD.n922 0.00526534
R9743 IOVDD.n927 IOVDD.n921 0.00526534
R9744 IOVDD.n873 IOVDD.n872 0.00526534
R9745 IOVDD.n874 IOVDD.n871 0.00526534
R9746 IOVDD.n875 IOVDD.n870 0.00526534
R9747 IOVDD.n875 IOVDD.n869 0.00526534
R9748 IOVDD.n877 IOVDD.n868 0.00526534
R9749 IOVDD.n214 IOVDD.n212 0.00521947
R9750 IOVDD.n154 IOVDD.n152 0.00521947
R9751 IOVDD.n591 IOVDD.n549 0.00521919
R9752 IOVDD.n546 IOVDD.n540 0.00521919
R9753 IOVDD.n21 IOVDD.n11 0.00517123
R9754 IOVDD.n83 IOVDD.n73 0.00517123
R9755 IOVDD.n908 IOVDD.n907 0.00516901
R9756 IOVDD.n1563 IOVDD.n855 0.00516901
R9757 IOVDD.n774 IOVDD.n282 0.00516812
R9758 IOVDD.n603 IOVDD.n573 0.00513339
R9759 IOVDD.n589 IOVDD.n550 0.00513339
R9760 IOVDD.n1324 IOVDD.n1310 0.00507755
R9761 IOVDD.n1353 IOVDD.n1336 0.00507755
R9762 IOVDD.n575 IOVDD.n572 0.00504758
R9763 IOVDD.n592 IOVDD.n551 0.00504758
R9764 IOVDD.n244 IOVDD.n224 0.00503795
R9765 IOVDD.n234 IOVDD.n226 0.00503795
R9766 IOVDD.n169 IOVDD.n168 0.00503795
R9767 IOVDD.n178 IOVDD.n177 0.00503795
R9768 IOVDD.n547 IOVDD.n546 0.00503226
R9769 IOVDD.n66 IOVDD 0.00502055
R9770 IOVDD.n61 IOVDD.n46 0.00502055
R9771 IOVDD.n60 IOVDD.n43 0.00502055
R9772 IOVDD.n123 IOVDD.n108 0.00502055
R9773 IOVDD.n122 IOVDD.n105 0.00502055
R9774 IOVDD.n602 IOVDD.n571 0.00496178
R9775 IOVDD.n590 IOVDD.n547 0.00494646
R9776 IOVDD.n1289 IOVDD.n1276 0.00493884
R9777 IOVDD.n1385 IOVDD.n1370 0.00493884
R9778 IOVDD.n588 IOVDD.n552 0.00487598
R9779 IOVDD.n934 IOVDD.n932 0.00487117
R9780 IOVDD.n881 IOVDD.n879 0.00487117
R9781 IOVDD.n22 IOVDD.n8 0.00486986
R9782 IOVDD.n84 IOVDD.n70 0.00486986
R9783 IOVDD.n208 IOVDD.n207 0.00485644
R9784 IOVDD.n148 IOVDD.n147 0.00485644
R9785 IOVDD.n688 IOVDD.n687 0.00483371
R9786 IOVDD.n1288 IOVDD.n1274 0.00480013
R9787 IOVDD.n1325 IOVDD.n1312 0.00480013
R9788 IOVDD.n1384 IOVDD.n1372 0.00480013
R9789 IOVDD.n1348 IOVDD.n1334 0.00480013
R9790 IOVDD.n576 IOVDD.n570 0.00479017
R9791 IOVDD.n593 IOVDD.n553 0.00479017
R9792 IOVDD.n1543 IOVDD.n1542 0.00476441
R9793 IOVDD.n1537 IOVDD.n1512 0.00476441
R9794 IOVDD.n830 IOVDD.n823 0.00476441
R9795 IOVDD.n833 IOVDD.n827 0.00476441
R9796 IOVDD.n601 IOVDD.n569 0.00470437
R9797 IOVDD.n587 IOVDD.n554 0.00470437
R9798 IOVDD.n577 IOVDD.n568 0.00461856
R9799 IOVDD.n685 IOVDD.n673 0.00460819
R9800 IOVDD.n1504 IOVDD 0.00459429
R9801 IOVDD.n1508 IOVDD.n960 0.00459429
R9802 IOVDD IOVDD.n960 0.00459429
R9803 IOVDD.n1404 IOVDD.n1087 0.00459429
R9804 IOVDD.n600 IOVDD.n567 0.00453276
R9805 IOVDD.n594 IOVDD.n555 0.00453276
R9806 IOVDD.n1323 IOVDD.n1309 0.0045227
R9807 IOVDD.n1347 IOVDD.n1337 0.0045227
R9808 IOVDD.n1661 IOVDD.n221 0.0044934
R9809 IOVDD.n216 IOVDD.n200 0.0044934
R9810 IOVDD.n191 IOVDD.n162 0.0044934
R9811 IOVDD.n156 IOVDD.n140 0.0044934
R9812 IOVDD.n1502 IOVDD.n1474 0.00445782
R9813 IOVDD.n1417 IOVDD.n1416 0.00445782
R9814 IOVDD.n966 IOVDD.n965 0.00445782
R9815 IOVDD.n586 IOVDD.n556 0.00444696
R9816 IOVDD.n788 IOVDD.n504 0.00442612
R9817 IOVDD.t220 IOVDD.t222 0.00442276
R9818 IOVDD.t222 IOVDD.t217 0.00442276
R9819 IOVDD.t221 IOVDD.t223 0.00442276
R9820 IOVDD.t223 IOVDD.t224 0.00442276
R9821 IOVDD.n28 IOVDD.n12 0.00441781
R9822 IOVDD.n90 IOVDD.n74 0.00441781
R9823 IOVDD.n1290 IOVDD.n1277 0.00438398
R9824 IOVDD.n1386 IOVDD.n1369 0.00438398
R9825 IOVDD.n578 IOVDD.n566 0.00436115
R9826 IOVDD.n595 IOVDD.n557 0.00436115
R9827 IOVDD.n1548 IOVDD.n1547 0.00432704
R9828 IOVDD.n245 IOVDD.n243 0.00431188
R9829 IOVDD.n236 IOVDD.n235 0.00431188
R9830 IOVDD.n167 IOVDD.n166 0.00431188
R9831 IOVDD.n180 IOVDD.n179 0.00431188
R9832 IOVDD.n599 IOVDD.n565 0.00427535
R9833 IOVDD.n585 IOVDD.n558 0.00427535
R9834 IOVDD.n51 IOVDD.n47 0.00426712
R9835 IOVDD.n53 IOVDD.n42 0.00426712
R9836 IOVDD.n113 IOVDD.n109 0.00426712
R9837 IOVDD.n115 IOVDD.n104 0.00426712
R9838 IOVDD.n1287 IOVDD.n1273 0.00424527
R9839 IOVDD.n1383 IOVDD.n1373 0.00424527
R9840 IOVDD.n579 IOVDD.n564 0.00418955
R9841 IOVDD.n1655 IOVDD.n135 0.00413036
R9842 IOVDD.n204 IOVDD.n203 0.00413036
R9843 IOVDD.n144 IOVDD.n143 0.00413036
R9844 IOVDD.n26 IOVDD.n7 0.00411644
R9845 IOVDD.n88 IOVDD.n69 0.00411644
R9846 IOVDD.n1326 IOVDD.n1313 0.00410656
R9847 IOVDD.n1352 IOVDD.n1333 0.00410656
R9848 IOVDD.n596 IOVDD.n559 0.00410374
R9849 IOVDD.n774 IOVDD.n298 0.00409086
R9850 IOVDD.n743 IOVDD.n688 0.00404438
R9851 IOVDD.n673 IOVDD.n672 0.00404438
R9852 IOVDD.n598 IOVDD.n563 0.00401794
R9853 IOVDD.n584 IOVDD.n560 0.00401794
R9854 IOVDD.n583 IOVDD.n581 0.00400259
R9855 IOVDD.n583 IOVDD.n582 0.00400259
R9856 IOVDD.n687 IOVDD.n674 0.00399564
R9857 IOVDD.n328 IOVDD.n282 0.00397116
R9858 IOVDD.n580 IOVDD.n562 0.00393214
R9859 IOVDD.n327 IOVDD.n299 0.00385147
R9860 IOVDD.n777 IOVDD.n776 0.00385147
R9861 IOVDD.n597 IOVDD.n561 0.00384633
R9862 IOVDD.n1291 IOVDD.n1278 0.00382913
R9863 IOVDD.n1322 IOVDD.n1308 0.00382913
R9864 IOVDD.n1387 IOVDD.n1368 0.00382913
R9865 IOVDD.n1354 IOVDD.n1338 0.00382913
R9866 IOVDD.n20 IOVDD.n13 0.00381507
R9867 IOVDD.n82 IOVDD.n75 0.00381507
R9868 IOVDD.n217 IOVDD.n215 0.00376733
R9869 IOVDD.n157 IOVDD.n155 0.00376733
R9870 IOVDD.n324 IOVDD.n281 0.00373177
R9871 IOVDD.n332 IOVDD.n294 0.00373177
R9872 IOVDD.n1286 IOVDD.n1272 0.00369042
R9873 IOVDD.n1382 IOVDD.n1374 0.00369042
R9874 IOVDD.n1542 IOVDD.n1541 0.00367097
R9875 IOVDD.n1535 IOVDD.n1512 0.00367097
R9876 IOVDD.n831 IOVDD.n823 0.00367097
R9877 IOVDD.n835 IOVDD.n827 0.00367097
R9878 IOVDD.n62 IOVDD.n48 0.00366438
R9879 IOVDD.n59 IOVDD.n41 0.00366438
R9880 IOVDD.n124 IOVDD.n110 0.00366438
R9881 IOVDD.n121 IOVDD.n103 0.00366438
R9882 IOVDD.n745 IOVDD.n716 0.00365736
R9883 IOVDD.n670 IOVDD.n616 0.00365736
R9884 IOVDD.n333 IOVDD.n293 0.00361208
R9885 IOVDD.n437 IOVDD.n436 0.00360617
R9886 IOVDD.n671 IOVDD.n617 0.00360097
R9887 IOVDD.n1657 IOVDD.n223 0.00358581
R9888 IOVDD.n231 IOVDD.n227 0.00358581
R9889 IOVDD.n165 IOVDD.n164 0.00358581
R9890 IOVDD.n182 IOVDD.n181 0.00358581
R9891 IOVDD.n1515 IOVDD.n1514 0.00357762
R9892 IOVDD.n1570 IOVDD.n1569 0.00357762
R9893 IOVDD.n1327 IOVDD.n1314 0.0035517
R9894 IOVDD.n1349 IOVDD.n1332 0.0035517
R9895 IOVDD.n717 IOVDD.n715 0.00354459
R9896 IOVDD.n669 IOVDD.n618 0.00354459
R9897 IOVDD.n23 IOVDD.n6 0.0035137
R9898 IOVDD.n85 IOVDD.n68 0.0035137
R9899 IOVDD.n762 IOVDD.n761 0.00350312
R9900 IOVDD.n323 IOVDD.n300 0.00349238
R9901 IOVDD.n718 IOVDD.n714 0.00348821
R9902 IOVDD.n668 IOVDD.n619 0.00348821
R9903 IOVDD.n434 IOVDD.n431 0.00345286
R9904 IOVDD.n719 IOVDD.n713 0.00343183
R9905 IOVDD.t32 IOVDD.n684 0.00342658
R9906 IOVDD.n761 IOVDD.n512 0.00341732
R9907 IOVDD.n205 IOVDD.n197 0.00340429
R9908 IOVDD.n145 IOVDD.n137 0.00340429
R9909 IOVDD.n667 IOVDD.n620 0.00337545
R9910 IOVDD.n320 IOVDD.n280 0.00337269
R9911 IOVDD.n336 IOVDD.n292 0.00337269
R9912 IOVDD.n720 IOVDD.n712 0.00331907
R9913 IOVDD.n666 IOVDD.n621 0.00331907
R9914 IOVDD.n762 IOVDD.n539 0.00327766
R9915 IOVDD.n1321 IOVDD.n1307 0.00327427
R9916 IOVDD.n1346 IOVDD.n1339 0.00327427
R9917 IOVDD.n721 IOVDD.n711 0.00326269
R9918 IOVDD.n665 IOVDD.n622 0.00326269
R9919 IOVDD.n319 IOVDD.n301 0.00325299
R9920 IOVDD.n337 IOVDD.n291 0.00325299
R9921 IOVDD.n1599 IOVDD 0.00325
R9922 IOVDD.n1473 IOVDD.n963 0.00322953
R9923 IOVDD.n1412 IOVDD.n1082 0.00322953
R9924 IOVDD.n1122 IOVDD.n1094 0.00322953
R9925 IOVDD.n1266 IOVDD.n1237 0.00322953
R9926 IOVDD.n29 IOVDD.n14 0.00321233
R9927 IOVDD.n91 IOVDD.n76 0.00321233
R9928 IOVDD.n722 IOVDD.n710 0.0032063
R9929 IOVDD.n743 IOVDD.n689 0.0032063
R9930 IOVDD.n672 IOVDD.n643 0.0032063
R9931 IOVDD.n723 IOVDD.n709 0.00314992
R9932 IOVDD.n744 IOVDD.n690 0.00314992
R9933 IOVDD.n664 IOVDD.n623 0.00314992
R9934 IOVDD.t49 IOVDD.n432 0.00314181
R9935 IOVDD.n1292 IOVDD.n1279 0.00313556
R9936 IOVDD.n1388 IOVDD.n1367 0.00313556
R9937 IOVDD.n340 IOVDD.n290 0.0031333
R9938 IOVDD.n742 IOVDD.n691 0.00309354
R9939 IOVDD.n644 IOVDD.n642 0.00309354
R9940 IOVDD.n663 IOVDD.n624 0.00309354
R9941 IOVDD.n1081 IOVDD.n1080 0.00309305
R9942 IOVDD.n1265 IOVDD.n1236 0.00309305
R9943 IOVDD.n581 IOVDD.n561 0.0030741
R9944 IOVDD.n479 IOVDD.n437 0.00306959
R9945 IOVDD.n431 IOVDD.n430 0.00306959
R9946 IOVDD.n50 IOVDD.n49 0.00306164
R9947 IOVDD.n54 IOVDD.n40 0.00306164
R9948 IOVDD.n112 IOVDD.n111 0.00306164
R9949 IOVDD.n116 IOVDD.n102 0.00306164
R9950 IOVDD.n724 IOVDD.n708 0.00303716
R9951 IOVDD.n741 IOVDD.n692 0.00303716
R9952 IOVDD.n645 IOVDD.n641 0.00303716
R9953 IOVDD.n662 IOVDD.n625 0.00303716
R9954 IOVDD.n316 IOVDD.n279 0.0030136
R9955 IOVDD.n341 IOVDD.n289 0.0030136
R9956 IOVDD.n1285 IOVDD.n1271 0.00299685
R9957 IOVDD.n1328 IOVDD.n1315 0.00299685
R9958 IOVDD.n1381 IOVDD.n1375 0.00299685
R9959 IOVDD.n1351 IOVDD.n1331 0.00299685
R9960 IOVDD.n597 IOVDD.n562 0.0029883
R9961 IOVDD.n725 IOVDD.n707 0.00298078
R9962 IOVDD.n646 IOVDD.n640 0.00298078
R9963 IOVDD.n661 IOVDD.n626 0.00298078
R9964 IOVDD.t65 IOVDD.n679 0.00297519
R9965 IOVDD.n1472 IOVDD.n1471 0.00295658
R9966 IOVDD.n1079 IOVDD.n1078 0.00295658
R9967 IOVDD.n1148 IOVDD.n1095 0.00295658
R9968 IOVDD.n1264 IOVDD.n1235 0.00295658
R9969 IOVDD.n1393 IOVDD.n1267 0.00295658
R9970 IOVDD.n726 IOVDD.n706 0.0029244
R9971 IOVDD.n740 IOVDD.n693 0.0029244
R9972 IOVDD.n25 IOVDD.n5 0.00291096
R9973 IOVDD.n87 IOVDD.n67 0.00291096
R9974 IOVDD.n580 IOVDD.n563 0.0029025
R9975 IOVDD.n582 IOVDD.n560 0.0029025
R9976 IOVDD.n315 IOVDD.n302 0.00289391
R9977 IOVDD.n739 IOVDD.n694 0.00286802
R9978 IOVDD.n647 IOVDD.n639 0.00286802
R9979 IOVDD.n660 IOVDD.n627 0.00286802
R9980 IOVDD.n219 IOVDD.n199 0.00285974
R9981 IOVDD.n159 IOVDD.n139 0.00285974
R9982 IOVDD.n1470 IOVDD.n1469 0.0028201
R9983 IOVDD.n1077 IOVDD.n1076 0.0028201
R9984 IOVDD.n1123 IOVDD.n1096 0.0028201
R9985 IOVDD.n1263 IOVDD.n1234 0.0028201
R9986 IOVDD.n598 IOVDD.n564 0.00281669
R9987 IOVDD.n584 IOVDD.n559 0.00281669
R9988 IOVDD.n727 IOVDD.n705 0.00281164
R9989 IOVDD.n738 IOVDD.n695 0.00281164
R9990 IOVDD.n648 IOVDD.n638 0.00281164
R9991 IOVDD.n659 IOVDD.n628 0.00281164
R9992 IOVDD.n305 IOVDD.n278 0.00277421
R9993 IOVDD.n344 IOVDD.n288 0.00277421
R9994 IOVDD.n728 IOVDD.n704 0.00275525
R9995 IOVDD.n649 IOVDD.n637 0.00275525
R9996 IOVDD.n658 IOVDD.n629 0.00275525
R9997 IOVDD.n596 IOVDD.n558 0.00273089
R9998 IOVDD.n1320 IOVDD.n1306 0.00271942
R9999 IOVDD.n1355 IOVDD.n1340 0.00271942
R10000 IOVDD.t61 IOVDD.n1511 0.00271594
R10001 IOVDD.n729 IOVDD.n703 0.00269887
R10002 IOVDD.n737 IOVDD.n696 0.00269887
R10003 IOVDD.n650 IOVDD.n636 0.00269887
R10004 IOVDD.n1468 IOVDD.n1467 0.00268362
R10005 IOVDD.n1419 IOVDD.n1418 0.00268362
R10006 IOVDD.n970 IOVDD.n969 0.00268362
R10007 IOVDD.n1024 IOVDD.n967 0.00268362
R10008 IOVDD.n1413 IOVDD.n1028 0.00268362
R10009 IOVDD.n1147 IOVDD.n1097 0.00268362
R10010 IOVDD.n1150 IOVDD.n1149 0.00268362
R10011 IOVDD.n1179 IOVDD.n1152 0.00268362
R10012 IOVDD.n1208 IOVDD.n1178 0.00268362
R10013 IOVDD.n1210 IOVDD.n1092 0.00268362
R10014 IOVDD.n233 IOVDD.n232 0.00267822
R10015 IOVDD.n184 IOVDD.n183 0.00267822
R10016 IOVDD.n304 IOVDD.n303 0.00265452
R10017 IOVDD.n345 IOVDD.n287 0.00265452
R10018 IOVDD.n494 IOVDD.n465 0.00264634
R10019 IOVDD.n415 IOVDD.n374 0.00264634
R10020 IOVDD.n579 IOVDD.n565 0.00264509
R10021 IOVDD.n730 IOVDD.n702 0.00264249
R10022 IOVDD.n736 IOVDD.n697 0.00264249
R10023 IOVDD.n657 IOVDD.n630 0.00264249
R10024 IOVDD.n416 IOVDD.n375 0.00260801
R10025 IOVDD.n735 IOVDD.n698 0.00258611
R10026 IOVDD.n651 IOVDD.n635 0.00258611
R10027 IOVDD.n656 IOVDD.n631 0.00258611
R10028 IOVDD.n1293 IOVDD.n1280 0.00258071
R10029 IOVDD.n1389 IOVDD.n1366 0.00258071
R10030 IOVDD.n493 IOVDD.n464 0.00256969
R10031 IOVDD.n414 IOVDD.n376 0.00256969
R10032 IOVDD.n599 IOVDD.n566 0.00255928
R10033 IOVDD.n585 IOVDD.n557 0.00255928
R10034 IOVDD.n1421 IOVDD.n1420 0.00254715
R10035 IOVDD.n1023 IOVDD.n1022 0.00254715
R10036 IOVDD.n1075 IOVDD.n1074 0.00254715
R10037 IOVDD.n1121 IOVDD.n1120 0.00254715
R10038 IOVDD.n1207 IOVDD.n1177 0.00254715
R10039 IOVDD.n1262 IOVDD.n1233 0.00254715
R10040 IOVDD.n348 IOVDD.n286 0.00253482
R10041 IOVDD.n466 IOVDD.n463 0.00253136
R10042 IOVDD.n417 IOVDD.n377 0.00253136
R10043 IOVDD.n731 IOVDD.n701 0.00252973
R10044 IOVDD.n734 IOVDD.n699 0.00252973
R10045 IOVDD.n652 IOVDD.n634 0.00252973
R10046 IOVDD.n655 IOVDD.n632 0.00252973
R10047 IOVDD.n492 IOVDD.n462 0.00249303
R10048 IOVDD.n931 IOVDD.n925 0.00248556
R10049 IOVDD.n930 IOVDD.n924 0.00248556
R10050 IOVDD.n926 IOVDD.n923 0.00248556
R10051 IOVDD.n927 IOVDD.n922 0.00248556
R10052 IOVDD.n928 IOVDD.n921 0.00248556
R10053 IOVDD.n878 IOVDD.n872 0.00248556
R10054 IOVDD.n873 IOVDD.n871 0.00248556
R10055 IOVDD.n874 IOVDD.n870 0.00248556
R10056 IOVDD.n877 IOVDD.n869 0.00248556
R10057 IOVDD.n876 IOVDD.n868 0.00248556
R10058 IOVDD.n1400 IOVDD.n1399 0.00248036
R10059 IOVDD.n578 IOVDD.n567 0.00247348
R10060 IOVDD.n595 IOVDD.n556 0.00247348
R10061 IOVDD.n732 IOVDD.n700 0.00247335
R10062 IOVDD.n653 IOVDD.n633 0.00247335
R10063 IOVDD.n654 IOVDD.n633 0.00247335
R10064 IOVDD.n19 IOVDD.n15 0.0024589
R10065 IOVDD.n81 IOVDD.n77 0.0024589
R10066 IOVDD.n413 IOVDD.n378 0.0024547
R10067 IOVDD.t75 IOVDD.n832 0.00244973
R10068 IOVDD.t61 IOVDD.n1509 0.00244973
R10069 IOVDD.n686 IOVDD.t32 0.00244973
R10070 IOVDD.n1284 IOVDD.n1270 0.00244199
R10071 IOVDD.n1380 IOVDD.n1376 0.00244199
R10072 IOVDD.n1575 IOVDD.n1574 0.00242169
R10073 IOVDD.n733 IOVDD.n700 0.00241697
R10074 IOVDD.n733 IOVDD.n699 0.00241697
R10075 IOVDD.n467 IOVDD.n461 0.00241638
R10076 IOVDD.n418 IOVDD.n379 0.00241638
R10077 IOVDD.n797 IOVDD.n277 0.00241513
R10078 IOVDD.n1466 IOVDD.n1465 0.00241067
R10079 IOVDD.n1423 IOVDD.n1422 0.00241067
R10080 IOVDD.n972 IOVDD.n971 0.00241067
R10081 IOVDD.n1021 IOVDD.n1020 0.00241067
R10082 IOVDD.n1030 IOVDD.n1029 0.00241067
R10083 IOVDD.n1073 IOVDD.n1072 0.00241067
R10084 IOVDD.n1124 IOVDD.n1098 0.00241067
R10085 IOVDD.n1135 IOVDD.n1119 0.00241067
R10086 IOVDD.n1180 IOVDD.n1153 0.00241067
R10087 IOVDD.n1206 IOVDD.n1176 0.00241067
R10088 IOVDD.n1239 IOVDD.n1211 0.00241067
R10089 IOVDD.n1261 IOVDD.n1232 0.00241067
R10090 IOVDD.n586 IOVDD.n555 0.00238768
R10091 IOVDD.n491 IOVDD.n460 0.00237805
R10092 IOVDD.n412 IOVDD.n380 0.00237805
R10093 IOVDD.n732 IOVDD.n701 0.00236058
R10094 IOVDD.n653 IOVDD.n634 0.00236058
R10095 IOVDD.n654 IOVDD.n632 0.00236058
R10096 IOVDD.n468 IOVDD.n459 0.00233972
R10097 IOVDD.n479 IOVDD.n438 0.00233972
R10098 IOVDD.n430 IOVDD.n401 0.00233972
R10099 IOVDD.n433 IOVDD.t49 0.00231603
R10100 IOVDD.n58 IOVDD.n39 0.00230822
R10101 IOVDD.n120 IOVDD.n101 0.00230822
R10102 IOVDD.n731 IOVDD.n702 0.0023042
R10103 IOVDD.n734 IOVDD.n698 0.0023042
R10104 IOVDD.n652 IOVDD.n635 0.0023042
R10105 IOVDD.n655 IOVDD.n631 0.0023042
R10106 IOVDD.n1299 IOVDD.n1297 0.00230328
R10107 IOVDD.n1363 IOVDD.n1360 0.00230328
R10108 IOVDD.n600 IOVDD.n568 0.00230187
R10109 IOVDD.n594 IOVDD.n554 0.00230187
R10110 IOVDD.n436 IOVDD.n435 0.00230178
R10111 IOVDD.n435 IOVDD.n434 0.00230178
R10112 IOVDD.n490 IOVDD.n458 0.00230139
R10113 IOVDD.n480 IOVDD.n439 0.00230139
R10114 IOVDD.n419 IOVDD.n381 0.00230139
R10115 IOVDD.n803 IOVDD.n802 0.00229543
R10116 IOVDD.n798 IOVDD.n276 0.00229543
R10117 IOVDD.n349 IOVDD.n285 0.00229543
R10118 IOVDD.n1464 IOVDD.n1463 0.00227419
R10119 IOVDD.n1425 IOVDD.n1424 0.00227419
R10120 IOVDD.n974 IOVDD.n973 0.00227419
R10121 IOVDD.n1019 IOVDD.n1018 0.00227419
R10122 IOVDD.n1032 IOVDD.n1031 0.00227419
R10123 IOVDD.n1071 IOVDD.n1070 0.00227419
R10124 IOVDD.n1146 IOVDD.n1099 0.00227419
R10125 IOVDD.n1136 IOVDD.n1118 0.00227419
R10126 IOVDD.n1181 IOVDD.n1154 0.00227419
R10127 IOVDD.n1205 IOVDD.n1175 0.00227419
R10128 IOVDD.n1240 IOVDD.n1212 0.00227419
R10129 IOVDD.n1260 IOVDD.n1231 0.00227419
R10130 IOVDD.n478 IOVDD.n440 0.00226307
R10131 IOVDD.n429 IOVDD.n400 0.00226307
R10132 IOVDD.n411 IOVDD.n382 0.00226307
R10133 IOVDD.n735 IOVDD.n697 0.00224782
R10134 IOVDD.n651 IOVDD.n636 0.00224782
R10135 IOVDD.n656 IOVDD.n630 0.00224782
R10136 IOVDD.n746 IOVDD.n512 0.00222899
R10137 IOVDD.n469 IOVDD.n457 0.00222474
R10138 IOVDD.n481 IOVDD.n441 0.00222474
R10139 IOVDD.n402 IOVDD.n399 0.00222474
R10140 IOVDD.n420 IOVDD.n383 0.00222474
R10141 IOVDD.n577 IOVDD.n569 0.00221607
R10142 IOVDD.n730 IOVDD.n703 0.00219144
R10143 IOVDD.n736 IOVDD.n696 0.00219144
R10144 IOVDD.n657 IOVDD.n629 0.00219144
R10145 IOVDD.n489 IOVDD.n456 0.00218641
R10146 IOVDD.n428 IOVDD.n398 0.00218641
R10147 IOVDD.n410 IOVDD.n384 0.00218641
R10148 IOVDD.n800 IOVDD.n799 0.00217573
R10149 IOVDD.n352 IOVDD.n284 0.00217573
R10150 IOVDD.n470 IOVDD.n455 0.00214808
R10151 IOVDD.n477 IOVDD.n442 0.00214808
R10152 IOVDD.n1462 IOVDD.n1461 0.00213772
R10153 IOVDD.n976 IOVDD.n975 0.00213772
R10154 IOVDD.n1034 IOVDD.n1033 0.00213772
R10155 IOVDD.n1125 IOVDD.n1100 0.00213772
R10156 IOVDD.n1182 IOVDD.n1155 0.00213772
R10157 IOVDD.n1241 IOVDD.n1213 0.00213772
R10158 IOVDD.n729 IOVDD.n704 0.00213506
R10159 IOVDD.n737 IOVDD.n695 0.00213506
R10160 IOVDD.n650 IOVDD.n637 0.00213506
R10161 IOVDD.n220 IOVDD.n218 0.00213366
R10162 IOVDD.n160 IOVDD.n158 0.00213366
R10163 IOVDD.n601 IOVDD.n570 0.00213027
R10164 IOVDD.n587 IOVDD.n553 0.00213027
R10165 IOVDD.n1572 IOVDD.n1571 0.002125
R10166 IOVDD.n482 IOVDD.n443 0.00210976
R10167 IOVDD.n403 IOVDD.n397 0.00210976
R10168 IOVDD.n421 IOVDD.n385 0.00210976
R10169 IOVDD.n728 IOVDD.n705 0.00207868
R10170 IOVDD.n649 IOVDD.n638 0.00207868
R10171 IOVDD.n658 IOVDD.n628 0.00207868
R10172 IOVDD.n488 IOVDD.n454 0.00207143
R10173 IOVDD.n476 IOVDD.n444 0.00207143
R10174 IOVDD.n427 IOVDD.n396 0.00207143
R10175 IOVDD.n409 IOVDD.n386 0.00207143
R10176 IOVDD.n353 IOVDD.n283 0.00205604
R10177 IOVDD.n517 IOVDD.n514 0.00205604
R10178 IOVDD.n576 IOVDD.n571 0.00204446
R10179 IOVDD.n593 IOVDD.n552 0.00204446
R10180 IOVDD.n471 IOVDD.n453 0.0020331
R10181 IOVDD.n404 IOVDD.n395 0.0020331
R10182 IOVDD.n422 IOVDD.n387 0.0020331
R10183 IOVDD.n1294 IOVDD.n1281 0.00202585
R10184 IOVDD.n1319 IOVDD.n1305 0.00202585
R10185 IOVDD.n1390 IOVDD.n1365 0.00202585
R10186 IOVDD.n1345 IOVDD.n1341 0.00202585
R10187 IOVDD.n727 IOVDD.n706 0.0020223
R10188 IOVDD.n738 IOVDD.n694 0.0020223
R10189 IOVDD.n648 IOVDD.n639 0.0020223
R10190 IOVDD.n659 IOVDD.n627 0.0020223
R10191 IOVDD.n1460 IOVDD.n1459 0.00200124
R10192 IOVDD.n1427 IOVDD.n1426 0.00200124
R10193 IOVDD.n1017 IOVDD.n1016 0.00200124
R10194 IOVDD.n1069 IOVDD.n1068 0.00200124
R10195 IOVDD.n1145 IOVDD.n1101 0.00200124
R10196 IOVDD.n1134 IOVDD.n1117 0.00200124
R10197 IOVDD.n1204 IOVDD.n1174 0.00200124
R10198 IOVDD.n1259 IOVDD.n1230 0.00200124
R10199 IOVDD.n487 IOVDD.n452 0.00199477
R10200 IOVDD.n483 IOVDD.n445 0.00199477
R10201 IOVDD.n426 IOVDD.n394 0.00199477
R10202 IOVDD.n739 IOVDD.n693 0.00196592
R10203 IOVDD.n647 IOVDD.n640 0.00196592
R10204 IOVDD.n660 IOVDD.n626 0.00196592
R10205 IOVDD.n588 IOVDD.n551 0.00195866
R10206 IOVDD.n472 IOVDD.n451 0.00195645
R10207 IOVDD.n475 IOVDD.n446 0.00195645
R10208 IOVDD.n408 IOVDD.n388 0.00195645
R10209 IOVDD.n229 IOVDD.n228 0.00195215
R10210 IOVDD.n186 IOVDD.n185 0.00195215
R10211 IOVDD.n834 IOVDD.t75 0.00194974
R10212 IOVDD.n1566 IOVDD.t57 0.00194868
R10213 IOVDD.n839 IOVDD.n818 0.0019459
R10214 IOVDD.n802 IOVDD.n273 0.00193634
R10215 IOVDD.n484 IOVDD.n447 0.00191812
R10216 IOVDD.n405 IOVDD.n393 0.00191812
R10217 IOVDD.n423 IOVDD.n389 0.00191812
R10218 IOVDD.n726 IOVDD.n707 0.00190953
R10219 IOVDD.n740 IOVDD.n692 0.00190953
R10220 IOVDD.n1283 IOVDD.n1269 0.00188714
R10221 IOVDD.n1379 IOVDD.n1377 0.00188714
R10222 IOVDD.n486 IOVDD.n450 0.00187979
R10223 IOVDD.n474 IOVDD.n448 0.00187979
R10224 IOVDD.n425 IOVDD.n392 0.00187979
R10225 IOVDD.n407 IOVDD.n390 0.00187979
R10226 IOVDD.n1571 IOVDD.n842 0.00187493
R10227 IOVDD.n602 IOVDD.n572 0.00187285
R10228 IOVDD.n1429 IOVDD.n1428 0.00186476
R10229 IOVDD.n978 IOVDD.n977 0.00186476
R10230 IOVDD.n1015 IOVDD.n1014 0.00186476
R10231 IOVDD.n1036 IOVDD.n1035 0.00186476
R10232 IOVDD.n1067 IOVDD.n1066 0.00186476
R10233 IOVDD.n1137 IOVDD.n1116 0.00186476
R10234 IOVDD.n1183 IOVDD.n1156 0.00186476
R10235 IOVDD.n1203 IOVDD.n1173 0.00186476
R10236 IOVDD.n1242 IOVDD.n1214 0.00186476
R10237 IOVDD.n1258 IOVDD.n1229 0.00186476
R10238 IOVDD.n30 IOVDD.n16 0.00185616
R10239 IOVDD.n92 IOVDD.n78 0.00185616
R10240 IOVDD.n725 IOVDD.n708 0.00185315
R10241 IOVDD.n646 IOVDD.n641 0.00185315
R10242 IOVDD.n661 IOVDD.n625 0.00185315
R10243 IOVDD.n473 IOVDD.n449 0.00184146
R10244 IOVDD.n406 IOVDD.n391 0.00184146
R10245 IOVDD.n424 IOVDD.n391 0.00184146
R10246 IOVDD.n485 IOVDD.n449 0.00180314
R10247 IOVDD.n485 IOVDD.n448 0.00180314
R10248 IOVDD.n724 IOVDD.n709 0.00179677
R10249 IOVDD.n741 IOVDD.n691 0.00179677
R10250 IOVDD.n645 IOVDD.n642 0.00179677
R10251 IOVDD.n662 IOVDD.n624 0.00179677
R10252 IOVDD.n605 IOVDD.n538 0.00178705
R10253 IOVDD.n575 IOVDD.n573 0.00178705
R10254 IOVDD.n592 IOVDD.n550 0.00178705
R10255 IOVDD.n503 IOVDD.n311 0.00177777
R10256 IOVDD.n473 IOVDD.n450 0.00176481
R10257 IOVDD.n406 IOVDD.n392 0.00176481
R10258 IOVDD.n424 IOVDD.n390 0.00176481
R10259 IOVDD.n1400 IOVDD.n1238 0.00175376
R10260 IOVDD.n742 IOVDD.n690 0.00174039
R10261 IOVDD.n644 IOVDD.n643 0.00174039
R10262 IOVDD.n663 IOVDD.n623 0.00174039
R10263 IOVDD.n1458 IOVDD.n1457 0.00172829
R10264 IOVDD.n1431 IOVDD.n1430 0.00172829
R10265 IOVDD.n980 IOVDD.n979 0.00172829
R10266 IOVDD.n1013 IOVDD.n1012 0.00172829
R10267 IOVDD.n1038 IOVDD.n1037 0.00172829
R10268 IOVDD.n1065 IOVDD.n1064 0.00172829
R10269 IOVDD.n1126 IOVDD.n1102 0.00172829
R10270 IOVDD.n1133 IOVDD.n1115 0.00172829
R10271 IOVDD.n1184 IOVDD.n1157 0.00172829
R10272 IOVDD.n1202 IOVDD.n1172 0.00172829
R10273 IOVDD.n1243 IOVDD.n1215 0.00172829
R10274 IOVDD.n1257 IOVDD.n1228 0.00172829
R10275 IOVDD.n486 IOVDD.n451 0.00172648
R10276 IOVDD.n474 IOVDD.n447 0.00172648
R10277 IOVDD.n425 IOVDD.n393 0.00172648
R10278 IOVDD.n407 IOVDD.n389 0.00172648
R10279 IOVDD.n55 IOVDD.n38 0.00170548
R10280 IOVDD.n117 IOVDD.n100 0.00170548
R10281 IOVDD.n603 IOVDD.n574 0.00170125
R10282 IOVDD.n589 IOVDD.n549 0.00170125
R10283 IOVDD.n946 IOVDD.n941 0.00169134
R10284 IOVDD.n942 IOVDD.n940 0.00169134
R10285 IOVDD.n945 IOVDD.n939 0.00169134
R10286 IOVDD.n943 IOVDD.n938 0.00169134
R10287 IOVDD.n944 IOVDD.n937 0.00169134
R10288 IOVDD.n919 IOVDD.n913 0.00169134
R10289 IOVDD.n918 IOVDD.n912 0.00169134
R10290 IOVDD.n914 IOVDD.n911 0.00169134
R10291 IOVDD.n917 IOVDD.n910 0.00169134
R10292 IOVDD.n915 IOVDD.n909 0.00169134
R10293 IOVDD.n894 IOVDD.n893 0.00169134
R10294 IOVDD.n889 IOVDD.n887 0.00169134
R10295 IOVDD.n890 IOVDD.n886 0.00169134
R10296 IOVDD.n892 IOVDD.n885 0.00169134
R10297 IOVDD.n891 IOVDD.n884 0.00169134
R10298 IOVDD.n866 IOVDD.n860 0.00169134
R10299 IOVDD.n861 IOVDD.n859 0.00169134
R10300 IOVDD.n862 IOVDD.n858 0.00169134
R10301 IOVDD.n863 IOVDD.n857 0.00169134
R10302 IOVDD.n865 IOVDD.n856 0.00169134
R10303 IOVDD.n484 IOVDD.n446 0.00168815
R10304 IOVDD.n405 IOVDD.n394 0.00168815
R10305 IOVDD.n423 IOVDD.n388 0.00168815
R10306 IOVDD.n723 IOVDD.n710 0.00168401
R10307 IOVDD.n744 IOVDD.n689 0.00168401
R10308 IOVDD.n664 IOVDD.n622 0.00168401
R10309 IOVDD.t75 IOVDD.n828 0.00166667
R10310 IOVDD.n1536 IOVDD.t61 0.00166667
R10311 IOVDD.n682 IOVDD.n681 0.00166667
R10312 IOVDD.n957 IOVDD.n819 0.00166667
R10313 IOVDD.n520 IOVDD.n271 0.00166667
R10314 IOVDD.n749 IOVDD.n513 0.00166667
R10315 IOVDD.n783 IOVDD.n782 0.00166667
R10316 IOVDD.n134 IOVDD.n130 0.00166667
R10317 IOVDD.n472 IOVDD.n452 0.00164983
R10318 IOVDD.n475 IOVDD.n445 0.00164983
R10319 IOVDD.n408 IOVDD.n387 0.00164983
R10320 IOVDD.n722 IOVDD.n711 0.00162763
R10321 IOVDD.n896 IOVDD.n818 0.00162501
R10322 IOVDD.n533 IOVDD.t31 0.00162501
R10323 IOVDD.t61 IOVDD.n1510 0.00162494
R10324 IOVDD.n591 IOVDD.n548 0.00161544
R10325 IOVDD.n544 IOVDD.n540 0.00161544
R10326 IOVDD.n487 IOVDD.n453 0.0016115
R10327 IOVDD.n483 IOVDD.n444 0.0016115
R10328 IOVDD.n426 IOVDD.n395 0.0016115
R10329 IOVDD.n1456 IOVDD.n1455 0.00159181
R10330 IOVDD.n982 IOVDD.n981 0.00159181
R10331 IOVDD.n1040 IOVDD.n1039 0.00159181
R10332 IOVDD.n1063 IOVDD.n1062 0.00159181
R10333 IOVDD.n1144 IOVDD.n1103 0.00159181
R10334 IOVDD.n1185 IOVDD.n1158 0.00159181
R10335 IOVDD.n1244 IOVDD.n1216 0.00159181
R10336 IOVDD.n1256 IOVDD.n1227 0.00159181
R10337 IOVDD.t75 IOVDD.n829 0.00158326
R10338 IOVDD.n545 IOVDD.t129 0.00158326
R10339 IOVDD.n1576 IOVDD.n1575 0.00157816
R10340 IOVDD.n471 IOVDD.n454 0.00157317
R10341 IOVDD.n404 IOVDD.n396 0.00157317
R10342 IOVDD.n422 IOVDD.n386 0.00157317
R10343 IOVDD.n721 IOVDD.n712 0.00157125
R10344 IOVDD.n665 IOVDD.n621 0.00157125
R10345 IOVDD.n488 IOVDD.n455 0.00153484
R10346 IOVDD.n476 IOVDD.n443 0.00153484
R10347 IOVDD.n427 IOVDD.n397 0.00153484
R10348 IOVDD.n409 IOVDD.n385 0.00153484
R10349 IOVDD.n792 IOVDD.n359 0.00153116
R10350 IOVDD.n605 IOVDD.n604 0.00152964
R10351 IOVDD.n720 IOVDD.n713 0.00151486
R10352 IOVDD.n666 IOVDD.n620 0.00151486
R10353 IOVDD.n1399 IOVDD.n962 0.0015107
R10354 IOVDD.n482 IOVDD.n442 0.00149652
R10355 IOVDD.n403 IOVDD.n398 0.00149652
R10356 IOVDD.n421 IOVDD.n384 0.00149652
R10357 IOVDD.n1318 IOVDD.n1304 0.001471
R10358 IOVDD.n1356 IOVDD.n1342 0.001471
R10359 IOVDD.n764 IOVDD.n359 0.00146881
R10360 IOVDD.n667 IOVDD.n619 0.00145848
R10361 IOVDD.n470 IOVDD.n456 0.00145819
R10362 IOVDD.n477 IOVDD.n441 0.00145819
R10363 IOVDD.n1454 IOVDD.n1453 0.00145534
R10364 IOVDD.n1433 IOVDD.n1432 0.00145534
R10365 IOVDD.n984 IOVDD.n983 0.00145534
R10366 IOVDD.n1011 IOVDD.n1010 0.00145534
R10367 IOVDD.n1042 IOVDD.n1041 0.00145534
R10368 IOVDD.n1127 IOVDD.n1104 0.00145534
R10369 IOVDD.n1138 IOVDD.n1114 0.00145534
R10370 IOVDD.n1186 IOVDD.n1159 0.00145534
R10371 IOVDD.n1201 IOVDD.n1171 0.00145534
R10372 IOVDD.n1245 IOVDD.n1217 0.00145534
R10373 IOVDD.n489 IOVDD.n457 0.00141986
R10374 IOVDD.n428 IOVDD.n399 0.00141986
R10375 IOVDD.n410 IOVDD.n383 0.00141986
R10376 IOVDD.n161 IOVDD.n138 0.00140759
R10377 IOVDD.n719 IOVDD.n714 0.0014021
R10378 IOVDD.n469 IOVDD.n458 0.00138153
R10379 IOVDD.n481 IOVDD.n440 0.00138153
R10380 IOVDD.n402 IOVDD.n400 0.00138153
R10381 IOVDD.n420 IOVDD.n382 0.00138153
R10382 IOVDD.n533 IOVDD.t17 0.00137498
R10383 IOVDD.n896 IOVDD.t57 0.00137497
R10384 IOVDD.n718 IOVDD.n715 0.00134572
R10385 IOVDD.n668 IOVDD.n618 0.00134572
R10386 IOVDD.n478 IOVDD.n439 0.00134321
R10387 IOVDD.n429 IOVDD.n401 0.00134321
R10388 IOVDD.n411 IOVDD.n381 0.00134321
R10389 IOVDD.n1576 IOVDD.n819 0.00133332
R10390 IOVDD.n535 IOVDD.n520 0.00133332
R10391 IOVDD.n782 IOVDD.n781 0.00133332
R10392 IOVDD.n783 IOVDD.n513 0.00133332
R10393 IOVDD.n134 IOVDD.n129 0.00133332
R10394 IOVDD.n683 IOVDD.n682 0.00133332
R10395 IOVDD.n1435 IOVDD.n1434 0.00131886
R10396 IOVDD.n1009 IOVDD.n1008 0.00131886
R10397 IOVDD.n1061 IOVDD.n1060 0.00131886
R10398 IOVDD.n1132 IOVDD.n1113 0.00131886
R10399 IOVDD.n1200 IOVDD.n1170 0.00131886
R10400 IOVDD.n1255 IOVDD.n1226 0.00131886
R10401 IOVDD.n490 IOVDD.n459 0.00130488
R10402 IOVDD.n480 IOVDD.n438 0.00130488
R10403 IOVDD.n419 IOVDD.n380 0.00130488
R10404 IOVDD.n906 IOVDD.n905 0.00129422
R10405 IOVDD.n1564 IOVDD.n854 0.00129422
R10406 IOVDD.n717 IOVDD.n716 0.00128934
R10407 IOVDD.n669 IOVDD.n617 0.00128934
R10408 IOVDD.n468 IOVDD.n460 0.00126655
R10409 IOVDD.n1238 IOVDD.n962 0.00124621
R10410 IOVDD.n671 IOVDD.n616 0.00123296
R10411 IOVDD.n491 IOVDD.n461 0.00122822
R10412 IOVDD.n412 IOVDD.n379 0.00122822
R10413 IOVDD.n230 IOVDD.n222 0.00122607
R10414 IOVDD.n781 IOVDD.n311 0.00122219
R10415 IOVDD.n678 IOVDD.n674 0.00121817
R10416 IOVDD.n467 IOVDD.n462 0.0011899
R10417 IOVDD.n418 IOVDD.n378 0.0011899
R10418 IOVDD.n1452 IOVDD.n1451 0.00118238
R10419 IOVDD.n1437 IOVDD.n1436 0.00118238
R10420 IOVDD.n986 IOVDD.n985 0.00118238
R10421 IOVDD.n1007 IOVDD.n1006 0.00118238
R10422 IOVDD.n1044 IOVDD.n1043 0.00118238
R10423 IOVDD.n1059 IOVDD.n1058 0.00118238
R10424 IOVDD.n1143 IOVDD.n1105 0.00118238
R10425 IOVDD.n1139 IOVDD.n1112 0.00118238
R10426 IOVDD.n1187 IOVDD.n1160 0.00118238
R10427 IOVDD.n1199 IOVDD.n1169 0.00118238
R10428 IOVDD.n1246 IOVDD.n1218 0.00118238
R10429 IOVDD.n1254 IOVDD.n1225 0.00118238
R10430 IOVDD.n413 IOVDD.n377 0.00115157
R10431 IOVDD.n492 IOVDD.n463 0.00111324
R10432 IOVDD.n57 IOVDD.n37 0.00110274
R10433 IOVDD.n119 IOVDD.n99 0.00110274
R10434 IOVDD.n778 IOVDD.n298 0.00109848
R10435 IOVDD.n466 IOVDD.n464 0.00107491
R10436 IOVDD.n417 IOVDD.n376 0.00107491
R10437 IOVDD.n1566 IOVDD.t126 0.00105127
R10438 IOVDD.n1450 IOVDD.n1449 0.00104591
R10439 IOVDD.n1439 IOVDD.n1438 0.00104591
R10440 IOVDD.n988 IOVDD.n987 0.00104591
R10441 IOVDD.n1005 IOVDD.n1004 0.00104591
R10442 IOVDD.n1027 IOVDD.n1026 0.00104591
R10443 IOVDD.n1046 IOVDD.n1045 0.00104591
R10444 IOVDD.n1057 IOVDD.n1056 0.00104591
R10445 IOVDD.n1128 IOVDD.n1106 0.00104591
R10446 IOVDD.n1131 IOVDD.n1111 0.00104591
R10447 IOVDD.n1188 IOVDD.n1161 0.00104591
R10448 IOVDD.n1198 IOVDD.n1168 0.00104591
R10449 IOVDD.n1091 IOVDD.n1090 0.00104591
R10450 IOVDD.n1247 IOVDD.n1219 0.00104591
R10451 IOVDD.n1253 IOVDD.n1224 0.00104591
R10452 IOVDD.n493 IOVDD.n465 0.00103658
R10453 IOVDD.n414 IOVDD.n375 0.00103658
R10454 IOVDD.n900 IOVDD.n842 0.001
R10455 IOVDD.n1574 IOVDD.n840 0.001
R10456 IOVDD.n959 IOVDD.n901 0.001
R10457 IOVDD.n1549 IOVDD.n950 0.001
R10458 IOVDD.n1550 IOVDD.n952 0.001
R10459 IOVDD.n955 IOVDD.n954 0.001
R10460 IOVDD.n958 IOVDD.n956 0.001
R10461 IOVDD.n959 IOVDD.n950 0.001
R10462 IOVDD.n1551 IOVDD.n951 0.001
R10463 IOVDD.n953 IOVDD.t62 0.001
R10464 IOVDD.t69 IOVDD.n902 0.001
R10465 IOVDD.n899 IOVDD.t43 0.001
R10466 IOVDD.n1523 IOVDD.t126 0.001
R10467 IOVDD.n958 IOVDD.n957 0.001
R10468 IOVDD.t69 IOVDD.n899 0.001
R10469 IOVDD.n956 IOVDD.n955 0.001
R10470 IOVDD.n902 IOVDD.t62 0.001
R10471 IOVDD.n954 IOVDD.n952 0.001
R10472 IOVDD.n953 IOVDD.n951 0.001
R10473 IOVDD.n1550 IOVDD.n1549 0.001
R10474 IOVDD.n1552 IOVDD.n1551 0.001
R10475 IOVDD.n1567 IOVDD.n898 0.001
R10476 IOVDD.n1553 IOVDD.n903 0.001
R10477 IOVDD.n1524 IOVDD.n895 0.001
R10478 IOVDD.n1567 IOVDD.n895 0.001
R10479 IOVDD.n1524 IOVDD.n903 0.001
R10480 IOVDD.n1523 IOVDD.t43 0.001
R10481 IOVDD.n1553 IOVDD.n898 0.001
R10482 IOVDD.n1572 IOVDD.n840 0.001
R10483 IOVDD.n901 IOVDD.n900 0.001
R10484 IOVDD.t93 IOVDD.n297 0.001
R10485 IOVDD.n794 IOVDD.n272 0.001
R10486 IOVDD.n274 IOVDD.n272 0.001
R10487 IOVDD.n801 IOVDD.n275 0.001
R10488 IOVDD.n796 IOVDD.n795 0.001
R10489 IOVDD.n314 IOVDD.n306 0.001
R10490 IOVDD.n318 IOVDD.n317 0.001
R10491 IOVDD.n322 IOVDD.n321 0.001
R10492 IOVDD.n326 IOVDD.n325 0.001
R10493 IOVDD.n330 IOVDD.n329 0.001
R10494 IOVDD.n775 IOVDD.n331 0.001
R10495 IOVDD.n335 IOVDD.n334 0.001
R10496 IOVDD.n339 IOVDD.n338 0.001
R10497 IOVDD.n343 IOVDD.n342 0.001
R10498 IOVDD.n347 IOVDD.n346 0.001
R10499 IOVDD.n351 IOVDD.n350 0.001
R10500 IOVDD.n355 IOVDD.n354 0.001
R10501 IOVDD.n515 IOVDD.n356 0.001
R10502 IOVDD.n793 IOVDD.n357 0.001
R10503 IOVDD.n681 IOVDD.n680 0.001
R10504 IOVDD.t129 IOVDD.n541 0.001
R10505 IOVDD.n543 IOVDD.n542 0.001
R10506 IOVDD.t50 IOVDD.n312 0.001
R10507 IOVDD.n521 IOVDD.n373 0.001
R10508 IOVDD.n522 IOVDD.n372 0.001
R10509 IOVDD.n523 IOVDD.n371 0.001
R10510 IOVDD.n524 IOVDD.t22 0.001
R10511 IOVDD.n525 IOVDD.n370 0.001
R10512 IOVDD.n526 IOVDD.t0 0.001
R10513 IOVDD.n527 IOVDD.t24 0.001
R10514 IOVDD.n528 IOVDD.n369 0.001
R10515 IOVDD.n529 IOVDD.n368 0.001
R10516 IOVDD.n530 IOVDD.n367 0.001
R10517 IOVDD.n531 IOVDD.t4 0.001
R10518 IOVDD.n532 IOVDD.n366 0.001
R10519 IOVDD.n534 IOVDD.t31 0.001
R10520 IOVDD.n608 IOVDD.t13 0.001
R10521 IOVDD.n607 IOVDD.n364 0.001
R10522 IOVDD.n606 IOVDD.n363 0.001
R10523 IOVDD.n610 IOVDD.n363 0.001
R10524 IOVDD.n611 IOVDD.t130 0.001
R10525 IOVDD.n612 IOVDD.n362 0.001
R10526 IOVDD.n613 IOVDD.n361 0.001
R10527 IOVDD.n614 IOVDD.t156 0.001
R10528 IOVDD.n615 IOVDD.t33 0.001
R10529 IOVDD.n747 IOVDD.t33 0.001
R10530 IOVDD.n519 IOVDD.t92 0.001
R10531 IOVDD.n764 IOVDD.n609 0.001
R10532 IOVDD.n532 IOVDD.t17 0.001
R10533 IOVDD.n531 IOVDD.n366 0.001
R10534 IOVDD.n530 IOVDD.t4 0.001
R10535 IOVDD.n529 IOVDD.n367 0.001
R10536 IOVDD.n528 IOVDD.n368 0.001
R10537 IOVDD.n527 IOVDD.n369 0.001
R10538 IOVDD.n526 IOVDD.t24 0.001
R10539 IOVDD.n525 IOVDD.t0 0.001
R10540 IOVDD.n524 IOVDD.n370 0.001
R10541 IOVDD.n523 IOVDD.t22 0.001
R10542 IOVDD.n522 IOVDD.n371 0.001
R10543 IOVDD.n521 IOVDD.n372 0.001
R10544 IOVDD.n373 IOVDD.n312 0.001
R10545 IOVDD.n606 IOVDD.n364 0.001
R10546 IOVDD.n607 IOVDD.t13 0.001
R10547 IOVDD.n608 IOVDD.n365 0.001
R10548 IOVDD.n609 IOVDD.n535 0.001
R10549 IOVDD.n534 IOVDD.n365 0.001
R10550 IOVDD.n615 IOVDD.n360 0.001
R10551 IOVDD.n614 IOVDD.t33 0.001
R10552 IOVDD.n613 IOVDD.t156 0.001
R10553 IOVDD.n612 IOVDD.n361 0.001
R10554 IOVDD.n611 IOVDD.n362 0.001
R10555 IOVDD.n610 IOVDD.t130 0.001
R10556 IOVDD.t155 IOVDD.n542 0.001
R10557 IOVDD.n543 IOVDD.n541 0.001
R10558 IOVDD.n680 IOVDD.t65 0.001
R10559 IOVDD.n498 IOVDD.n496 0.001
R10560 IOVDD.n498 IOVDD.n307 0.001
R10561 IOVDD.n790 IOVDD.n789 0.001
R10562 IOVDD.n499 IOVDD.n308 0.001
R10563 IOVDD.n784 IOVDD.n508 0.001
R10564 IOVDD.n500 IOVDD.n309 0.001
R10565 IOVDD.n785 IOVDD.n507 0.001
R10566 IOVDD.n501 IOVDD.n313 0.001
R10567 IOVDD.n786 IOVDD.n506 0.001
R10568 IOVDD.n502 IOVDD.n310 0.001
R10569 IOVDD.n787 IOVDD.n505 0.001
R10570 IOVDD.n750 IOVDD.n749 0.001
R10571 IOVDD.n752 IOVDD.n751 0.001
R10572 IOVDD.n754 IOVDD.n753 0.001
R10573 IOVDD.n756 IOVDD.n755 0.001
R10574 IOVDD.n758 IOVDD.n757 0.001
R10575 IOVDD.n760 IOVDD.n759 0.001
R10576 IOVDD.n763 IOVDD.n748 0.001
R10577 IOVDD.n764 IOVDD.n763 0.001
R10578 IOVDD.n760 IOVDD.n748 0.001
R10579 IOVDD.n759 IOVDD.n758 0.001
R10580 IOVDD.n757 IOVDD.n756 0.001
R10581 IOVDD.n755 IOVDD.n754 0.001
R10582 IOVDD.n753 IOVDD.n752 0.001
R10583 IOVDD.n751 IOVDD.n750 0.001
R10584 IOVDD.n747 IOVDD.n360 0.001
R10585 IOVDD.n787 IOVDD.n503 0.001
R10586 IOVDD.n786 IOVDD.n502 0.001
R10587 IOVDD.n785 IOVDD.n501 0.001
R10588 IOVDD.n784 IOVDD.n500 0.001
R10589 IOVDD.n508 IOVDD.n308 0.001
R10590 IOVDD.n789 IOVDD.n499 0.001
R10591 IOVDD.n790 IOVDD.n307 0.001
R10592 IOVDD.n792 IOVDD.n496 0.001
R10593 IOVDD.n794 IOVDD.n271 0.001
R10594 IOVDD.n297 IOVDD.n296 0.001
R10595 IOVDD.t114 IOVDD.n519 0.001
R10596 IOVDD.n801 IOVDD.n274 0.001
R10597 IOVDD.n796 IOVDD.n275 0.001
R10598 IOVDD.n795 IOVDD.n306 0.001
R10599 IOVDD.n317 IOVDD.n314 0.001
R10600 IOVDD.n321 IOVDD.n318 0.001
R10601 IOVDD.n325 IOVDD.n322 0.001
R10602 IOVDD.n329 IOVDD.n326 0.001
R10603 IOVDD.n775 IOVDD.n330 0.001
R10604 IOVDD.n334 IOVDD.n331 0.001
R10605 IOVDD.n338 IOVDD.n335 0.001
R10606 IOVDD.n342 IOVDD.n339 0.001
R10607 IOVDD.n346 IOVDD.n343 0.001
R10608 IOVDD.n350 IOVDD.n347 0.001
R10609 IOVDD.n354 IOVDD.n351 0.001
R10610 IOVDD.n515 IOVDD.n355 0.001
R10611 IOVDD.n357 IOVDD.n356 0.001
R10612 IOVDD.n505 IOVDD.n310 0.001
R10613 IOVDD.n506 IOVDD.n313 0.001
R10614 IOVDD.n507 IOVDD.n309 0.001
R10615 IOVDD.n793 IOVDD.n792 0.001
R10616 IOVDD.n133 IOVDD.n131 0.001
R10617 IOVDD.n1676 IOVDD.n132 0.001
R10618 IOVDD.n1675 IOVDD.n129 0.001
R10619 IOVDD.n133 IOVDD.n130 0.001
R10620 IOVDD.n132 IOVDD.n131 0.001
R10621 IOVDD.n1676 IOVDD.n1675 0.001
R10622 IOVDD.n416 IOVDD.n374 0.000998258
R10623 IOVDD.n935 IOVDD.n933 0.00099639
R10624 IOVDD.n882 IOVDD.n880 0.00099639
R10625 IOVDD.n1301 IOVDD.n1298 0.000916141
R10626 IOVDD.n1361 IOVDD.n1359 0.000916141
R10627 IOVDD.n1448 IOVDD.n1447 0.000909429
R10628 IOVDD.n990 IOVDD.n989 0.000909429
R10629 IOVDD.n1048 IOVDD.n1047 0.000909429
R10630 IOVDD.n1142 IOVDD.n1107 0.000909429
R10631 IOVDD.n1403 IOVDD.n1088 0.000909429
R10632 IOVDD.n1189 IOVDD.n1162 0.000909429
R10633 IOVDD.n1248 IOVDD.n1220 0.000909429
R10634 IOVDD.n685 IOVDD.n674 0.000838288
R10635 IOVDD.n1441 IOVDD.n1440 0.000772953
R10636 IOVDD.n997 IOVDD.n996 0.000772953
R10637 IOVDD.n1003 IOVDD.n1002 0.000772953
R10638 IOVDD.n1055 IOVDD.n1054 0.000772953
R10639 IOVDD.n1140 IOVDD.n1110 0.000772953
R10640 IOVDD.n1193 IOVDD.n1165 0.000772953
R10641 IOVDD.n1197 IOVDD.n1167 0.000772953
R10642 IOVDD.n1252 IOVDD.n1223 0.000772953
R10643 IOVDD.n1443 IOVDD.n1442 0.000636476
R10644 IOVDD.n1416 IOVDD.n964 0.000636476
R10645 IOVDD.n995 IOVDD.n994 0.000636476
R10646 IOVDD.n1050 IOVDD.n1049 0.000636476
R10647 IOVDD.n1130 IOVDD.n1109 0.000636476
R10648 IOVDD.n1192 IOVDD.n1164 0.000636476
R10649 IOVDD.n1251 IOVDD.n1222 0.000636476
R10650 ldo_brahim_0.ldo_brahim_opamp_2_stage_0/ldo_brahim_tail_0.tail.t3 ldo_brahim_0.ldo_brahim_opamp_2_stage_0/ldo_brahim_tail_0.tail.n12 17.0005
R10651 ldo_brahim_0.ldo_brahim_opamp_2_stage_0/ldo_brahim_tail_0.tail.n15 ldo_brahim_0.ldo_brahim_opamp_2_stage_0/ldo_brahim_tail_0.tail.t0 17.0005
R10652 ldo_brahim_0.ldo_brahim_opamp_2_stage_0/ldo_brahim_tail_0.tail.t3 ldo_brahim_0.ldo_brahim_opamp_2_stage_0/ldo_brahim_tail_0.tail.n10 8.49059
R10653 ldo_brahim_0.ldo_brahim_opamp_2_stage_0/ldo_brahim_tail_0.tail.t3 ldo_brahim_0.ldo_brahim_opamp_2_stage_0/ldo_brahim_tail_0.tail.n8 8.49059
R10654 ldo_brahim_0.ldo_brahim_opamp_2_stage_0/ldo_brahim_tail_0.tail.n13 ldo_brahim_0.ldo_brahim_opamp_2_stage_0/ldo_brahim_tail_0.tail.t3 8.49059
R10655 ldo_brahim_0.ldo_brahim_opamp_2_stage_0/ldo_brahim_tail_0.tail.t0 ldo_brahim_0.ldo_brahim_opamp_2_stage_0/ldo_brahim_tail_0.tail.n4 8.49059
R10656 ldo_brahim_0.ldo_brahim_opamp_2_stage_0/ldo_brahim_tail_0.tail.t0 ldo_brahim_0.ldo_brahim_opamp_2_stage_0/ldo_brahim_tail_0.tail.n5 8.49059
R10657 ldo_brahim_0.ldo_brahim_opamp_2_stage_0/ldo_brahim_tail_0.tail.t0 ldo_brahim_0.ldo_brahim_opamp_2_stage_0/ldo_brahim_tail_0.tail.n6 8.49059
R10658 ldo_brahim_0.ldo_brahim_opamp_2_stage_0/ldo_brahim_tail_0.tail.t0 ldo_brahim_0.ldo_brahim_opamp_2_stage_0/ldo_brahim_tail_0.tail.n14 8.49059
R10659 ldo_brahim_0.ldo_brahim_opamp_2_stage_0/ldo_brahim_tail_0.tail.t3 ldo_brahim_0.ldo_brahim_opamp_2_stage_0/ldo_brahim_tail_0.tail.n9 8.49045
R10660 ldo_brahim_0.ldo_brahim_opamp_2_stage_0/ldo_brahim_tail_0.tail.t3 ldo_brahim_0.ldo_brahim_opamp_2_stage_0/ldo_brahim_tail_0.tail.n3 8.49045
R10661 ldo_brahim_0.ldo_brahim_opamp_2_stage_0/ldo_brahim_tail_0.tail.t0 ldo_brahim_0.ldo_brahim_opamp_2_stage_0/ldo_brahim_tail_0.tail.n7 8.49045
R10662 ldo_brahim_0.ldo_brahim_opamp_2_stage_0/ldo_brahim_tail_0.tail.n1 ldo_brahim_0.ldo_brahim_opamp_2_stage_0/ldo_brahim_tail_0.tail.n0 8.26921
R10663 ldo_brahim_0.ldo_brahim_opamp_2_stage_0/ldo_brahim_tail_0.tail.n0 ldo_brahim_0.ldo_brahim_opamp_2_stage_0/ldo_brahim_tail_0.tail.t1 6.03286
R10664 ldo_brahim_0.ldo_brahim_opamp_2_stage_0/ldo_brahim_tail_0.tail.t0 ldo_brahim_0.ldo_brahim_opamp_2_stage_0/ldo_brahim_tail_0.tail.n2 5.66867
R10665 ldo_brahim_0.ldo_brahim_opamp_2_stage_0/ldo_brahim_tail_0.tail.t3 ldo_brahim_0.ldo_brahim_opamp_2_stage_0/ldo_brahim_tail_0.tail.n2 5.66811
R10666 ldo_brahim_0.ldo_brahim_opamp_2_stage_0/ldo_brahim_tail_0.tail.n0 ldo_brahim_0.ldo_brahim_opamp_2_stage_0/ldo_brahim_tail_0.tail.t2 1.38462
R10667 ldo_brahim_0.ldo_brahim_opamp_2_stage_0/ldo_brahim_tail_0.tail ldo_brahim_0.ldo_brahim_opamp_2_stage_0/ldo_brahim_tail_0.tail.n16 1.28279
R10668 ldo_brahim_0.ldo_brahim_opamp_2_stage_0/ldo_brahim_tail_0.tail.n11 ldo_brahim_0.ldo_brahim_opamp_2_stage_0/ldo_brahim_tail_0.tail.t4 1.21777
R10669 ldo_brahim_0.ldo_brahim_opamp_2_stage_0/ldo_brahim_tail_0.tail.n11 ldo_brahim_0.ldo_brahim_opamp_2_stage_0/ldo_brahim_tail_0.tail.t5 1.21769
R10670 ldo_brahim_0.ldo_brahim_opamp_2_stage_0/ldo_brahim_tail_0.tail ldo_brahim_0.ldo_brahim_opamp_2_stage_0/ldo_brahim_tail_0.tail.n1 0.539526
R10671 ldo_brahim_0.ldo_brahim_opamp_2_stage_0/ldo_brahim_tail_0.tail.n12 ldo_brahim_0.ldo_brahim_opamp_2_stage_0/ldo_brahim_tail_0.tail.n11 0.400135
R10672 ldo_brahim_0.ldo_brahim_opamp_2_stage_0/ldo_brahim_tail_0.tail.n16 ldo_brahim_0.ldo_brahim_opamp_2_stage_0/ldo_brahim_tail_0.tail.n2 0.0637887
R10673 ldo_brahim_0.ldo_brahim_opamp_2_stage_0/ldo_brahim_tail_0.tail.n8 ldo_brahim_0.ldo_brahim_opamp_2_stage_0/ldo_brahim_tail_0.tail.n7 0.0434219
R10674 ldo_brahim_0.ldo_brahim_opamp_2_stage_0/ldo_brahim_tail_0.tail.n9 ldo_brahim_0.ldo_brahim_opamp_2_stage_0/ldo_brahim_tail_0.tail.n6 0.0434219
R10675 ldo_brahim_0.ldo_brahim_opamp_2_stage_0/ldo_brahim_tail_0.tail.n9 ldo_brahim_0.ldo_brahim_opamp_2_stage_0/ldo_brahim_tail_0.tail.n5 0.0434219
R10676 ldo_brahim_0.ldo_brahim_opamp_2_stage_0/ldo_brahim_tail_0.tail.n13 ldo_brahim_0.ldo_brahim_opamp_2_stage_0/ldo_brahim_tail_0.tail.n7 0.0434219
R10677 ldo_brahim_0.ldo_brahim_opamp_2_stage_0/ldo_brahim_tail_0.tail.n14 ldo_brahim_0.ldo_brahim_opamp_2_stage_0/ldo_brahim_tail_0.tail.n3 0.0434219
R10678 ldo_brahim_0.ldo_brahim_opamp_2_stage_0/ldo_brahim_tail_0.tail.n14 ldo_brahim_0.ldo_brahim_opamp_2_stage_0/ldo_brahim_tail_0.tail.n13 0.0431332
R10679 ldo_brahim_0.ldo_brahim_opamp_2_stage_0/ldo_brahim_tail_0.tail.n10 ldo_brahim_0.ldo_brahim_opamp_2_stage_0/ldo_brahim_tail_0.tail.n5 0.0431332
R10680 ldo_brahim_0.ldo_brahim_opamp_2_stage_0/ldo_brahim_tail_0.tail.n10 ldo_brahim_0.ldo_brahim_opamp_2_stage_0/ldo_brahim_tail_0.tail.n4 0.0431332
R10681 ldo_brahim_0.ldo_brahim_opamp_2_stage_0/ldo_brahim_tail_0.tail.n8 ldo_brahim_0.ldo_brahim_opamp_2_stage_0/ldo_brahim_tail_0.tail.n6 0.0431332
R10682 ldo_brahim_0.ldo_brahim_opamp_2_stage_0/ldo_brahim_tail_0.tail.n1 ldo_brahim_0.ldo_brahim_opamp_2_stage_0/ldo_brahim_tail_0.tail 0.0256429
R10683 ldo_brahim_0.ldo_brahim_opamp_2_stage_0/ldo_brahim_tail_0.tail.n15 ldo_brahim_0.ldo_brahim_opamp_2_stage_0/ldo_brahim_tail_0.tail.n3 0.0221053
R10684 ldo_brahim_0.ldo_brahim_opamp_2_stage_0/ldo_brahim_tail_0.tail.n12 ldo_brahim_0.ldo_brahim_opamp_2_stage_0/ldo_brahim_tail_0.tail.n4 0.0218166
R10685 ldo_brahim_0.ldo_brahim_opamp_2_stage_0/ldo_brahim_tail_0.tail.n16 ldo_brahim_0.ldo_brahim_opamp_2_stage_0/ldo_brahim_tail_0.tail.n15 0.00339474
R10686 bgr_djalal_0.bgr_djalal_ota_1_stage_0.Vout1.n4 bgr_djalal_0.bgr_djalal_ota_1_stage_0.Vout1.t0 25.9468
R10687 bgr_djalal_0.bgr_djalal_ota_1_stage_0.Vout1.n0 bgr_djalal_0.bgr_djalal_ota_1_stage_0.Vout1.t3 20.2367
R10688 bgr_djalal_0.bgr_djalal_ota_1_stage_0.Vout1 bgr_djalal_0.bgr_djalal_ota_1_stage_0.Vout1.n2 11.0778
R10689 bgr_djalal_0.bgr_djalal_ota_1_stage_0.Vout1.n2 bgr_djalal_0.bgr_djalal_ota_1_stage_0.Vout1.n1 10.7392
R10690 bgr_djalal_0.bgr_djalal_ota_1_stage_0.Vout1.n0 bgr_djalal_0.bgr_djalal_ota_1_stage_0.Vout1.t2 10.2271
R10691 bgr_djalal_0.bgr_djalal_ota_1_stage_0.Vout1.n2 bgr_djalal_0.bgr_djalal_ota_1_stage_0.Vout1 10.2259
R10692 bgr_djalal_0.bgr_djalal_ota_1_stage_0.Vout1 bgr_djalal_0.bgr_djalal_ota_1_stage_0.Vout1.t4 9.0581
R10693 bgr_djalal_0.bgr_djalal_ota_1_stage_0.Vout1.n1 bgr_djalal_0.bgr_djalal_ota_1_stage_0.Vout1.t5 6.76155
R10694 bgr_djalal_0.bgr_djalal_ota_1_stage_0.Vout1 bgr_djalal_0.bgr_djalal_ota_1_stage_0.Vout1.t11 5.1482
R10695 bgr_djalal_0.bgr_djalal_ota_1_stage_0.Vout1.n5 bgr_djalal_0.bgr_djalal_ota_1_stage_0.Vout1.n4 4.25641
R10696 bgr_djalal_0.bgr_djalal_ota_1_stage_0.Vout1.n3 bgr_djalal_0.bgr_djalal_ota_1_stage_0.Vout1 3.82012
R10697 bgr_djalal_0.bgr_djalal_ota_1_stage_0.Vout1.t8 bgr_djalal_0.bgr_djalal_ota_1_stage_0.Vout1.t7 3.73463
R10698 bgr_djalal_0.bgr_djalal_ota_1_stage_0.Vout1.n5 bgr_djalal_0.bgr_djalal_ota_1_stage_0.Vout1.n3 1.65993
R10699 bgr_djalal_0.bgr_djalal_ota_1_stage_0.Vout1.n1 bgr_djalal_0.bgr_djalal_ota_1_stage_0.Vout1 0.847392
R10700 bgr_djalal_0.bgr_djalal_ota_1_stage_0.Vout1 bgr_djalal_0.bgr_djalal_ota_1_stage_0.Vout1.n0 0.7749
R10701 bgr_djalal_0.bgr_djalal_ota_1_stage_0.Vout1.n3 bgr_djalal_0.bgr_djalal_ota_1_stage_0.Vout1 0.1897
R10702 bgr_djalal_0.bgr_djalal_ota_1_stage_0.Vout1.n4 bgr_djalal_0.bgr_djalal_ota_1_stage_0.Vout1.t1 0.166455
R10703 bgr_djalal_0.bgr_djalal_ota_1_stage_0.Vout1.t6 bgr_djalal_0.bgr_djalal_ota_1_stage_0.Vout1.t10 0.0445
R10704 bgr_djalal_0.bgr_djalal_ota_1_stage_0.Vout1.t5 bgr_djalal_0.bgr_djalal_ota_1_stage_0.Vout1.t9 0.0445
R10705 bgr_djalal_0.bgr_djalal_ota_1_stage_0.Vout1 bgr_djalal_0.bgr_djalal_ota_1_stage_0.Vout1.n5 0.0364184
R10706 bgr_djalal_0.bgr_djalal_ota_1_stage_0.Vout1.t7 bgr_djalal_0.bgr_djalal_ota_1_stage_0.Vout1.t6 0.0298333
R10707 bgr_djalal_0.bgr_djalal_ota_1_stage_0.Vout1.t5 bgr_djalal_0.bgr_djalal_ota_1_stage_0.Vout1.t8 0.0298333
R10708 a_8732_8142.t0 a_8732_8142.t1 30.3632
R10709 a_11060_8142.t0 a_11060_8142.t1 30.559
R10710 ldo_brahim_0.ldo_brahim_pass_element2_0.VG2.n6 ldo_brahim_0.ldo_brahim_pass_element2_0.VG2.t5 37.5731
R10711 ldo_brahim_0.ldo_brahim_pass_element2_0.VG2.n35 ldo_brahim_0.ldo_brahim_pass_element2_0.VG2.n6 19.9179
R10712 ldo_brahim_0.ldo_brahim_pass_element2_0.VG2 ldo_brahim_0.ldo_brahim_pass_element2_0.VG2.n36 18.9954
R10713 ldo_brahim_0.ldo_brahim_pass_element2_0.VG2.n34 ldo_brahim_0.ldo_brahim_pass_element2_0.VG2.t10 12.045
R10714 ldo_brahim_0.ldo_brahim_pass_element2_0.VG2.n38 ldo_brahim_0.ldo_brahim_pass_element2_0.VG2.n37 11.4491
R10715 ldo_brahim_0.ldo_brahim_pass_element2_0.VG2.n36 ldo_brahim_0.ldo_brahim_pass_element2_0.VG2.t4 9.04236
R10716 ldo_brahim_0.ldo_brahim_pass_element2_0.VG2.t9 ldo_brahim_0.ldo_brahim_pass_element2_0.VG2.n0 8.45541
R10717 ldo_brahim_0.ldo_brahim_pass_element2_0.VG2.n2 ldo_brahim_0.ldo_brahim_pass_element2_0.VG2.n1 8.45095
R10718 ldo_brahim_0.ldo_brahim_pass_element2_0.VG2.n4 ldo_brahim_0.ldo_brahim_pass_element2_0.VG2.n3 8.37662
R10719 ldo_brahim_0.ldo_brahim_pass_element2_0.VG2.n3 ldo_brahim_0.ldo_brahim_pass_element2_0.VG2.n2 7.25919
R10720 ldo_brahim_0.ldo_brahim_pass_element2_0.VG2.n39 ldo_brahim_0.ldo_brahim_pass_element2_0.VG2.n38 7.25599
R10721 ldo_brahim_0.ldo_brahim_pass_element2_0.VG2.n40 ldo_brahim_0.ldo_brahim_pass_element2_0.VG2.n39 6.9495
R10722 ldo_brahim_0.ldo_brahim_pass_element2_0.VG2.n37 ldo_brahim_0.ldo_brahim_pass_element2_0.VG2.t0 6.00046
R10723 ldo_brahim_0.ldo_brahim_pass_element2_0.VG2.t10 ldo_brahim_0.ldo_brahim_pass_element2_0.VG2.n33 5.99791
R10724 ldo_brahim_0.ldo_brahim_pass_element2_0.VG2.t10 ldo_brahim_0.ldo_brahim_pass_element2_0.VG2.n18 5.99748
R10725 ldo_brahim_0.ldo_brahim_pass_element2_0.VG2.t10 ldo_brahim_0.ldo_brahim_pass_element2_0.VG2.n19 5.99748
R10726 ldo_brahim_0.ldo_brahim_pass_element2_0.VG2.t10 ldo_brahim_0.ldo_brahim_pass_element2_0.VG2.n15 5.99698
R10727 ldo_brahim_0.ldo_brahim_pass_element2_0.VG2.t10 ldo_brahim_0.ldo_brahim_pass_element2_0.VG2.n16 5.99698
R10728 ldo_brahim_0.ldo_brahim_pass_element2_0.VG2.n1 ldo_brahim_0.ldo_brahim_pass_element2_0.VG2.n0 5.55907
R10729 ldo_brahim_0.ldo_brahim_pass_element2_0.VG2.n36 ldo_brahim_0.ldo_brahim_pass_element2_0.VG2.n35 5.48849
R10730 ldo_brahim_0.ldo_brahim_pass_element2_0.VG2.t10 ldo_brahim_0.ldo_brahim_pass_element2_0.VG2.n22 5.43705
R10731 ldo_brahim_0.ldo_brahim_pass_element2_0.VG2 ldo_brahim_0.ldo_brahim_pass_element2_0.VG2.n5 5.29038
R10732 ldo_brahim_0.ldo_brahim_pass_element2_0.VG2.n35 ldo_brahim_0.ldo_brahim_pass_element2_0.VG2 4.59101
R10733 ldo_brahim_0.ldo_brahim_pass_element2_0.VG2.t10 ldo_brahim_0.ldo_brahim_pass_element2_0.VG2.n17 3.98767
R10734 ldo_brahim_0.ldo_brahim_pass_element2_0.VG2.t10 ldo_brahim_0.ldo_brahim_pass_element2_0.VG2.n10 2.99901
R10735 ldo_brahim_0.ldo_brahim_pass_element2_0.VG2.t10 ldo_brahim_0.ldo_brahim_pass_element2_0.VG2.n9 2.99901
R10736 ldo_brahim_0.ldo_brahim_pass_element2_0.VG2.t10 ldo_brahim_0.ldo_brahim_pass_element2_0.VG2.n8 2.99901
R10737 ldo_brahim_0.ldo_brahim_pass_element2_0.VG2.t10 ldo_brahim_0.ldo_brahim_pass_element2_0.VG2.n11 2.99901
R10738 ldo_brahim_0.ldo_brahim_pass_element2_0.VG2.n6 ldo_brahim_0.ldo_brahim_pass_element2_0.VG2 2.85288
R10739 ldo_brahim_0.ldo_brahim_pass_element2_0.VG2.n21 ldo_brahim_0.ldo_brahim_pass_element2_0.VG2.n17 2.80589
R10740 ldo_brahim_0.ldo_brahim_pass_element2_0.VG2.n29 ldo_brahim_0.ldo_brahim_pass_element2_0.VG2.n8 2.78969
R10741 ldo_brahim_0.ldo_brahim_pass_element2_0.VG2.n25 ldo_brahim_0.ldo_brahim_pass_element2_0.VG2.n24 2.73626
R10742 ldo_brahim_0.ldo_brahim_pass_element2_0.VG2.n30 ldo_brahim_0.ldo_brahim_pass_element2_0.VG2.n29 2.73109
R10743 ldo_brahim_0.ldo_brahim_pass_element2_0.VG2.n26 ldo_brahim_0.ldo_brahim_pass_element2_0.VG2.n25 2.73109
R10744 ldo_brahim_0.ldo_brahim_pass_element2_0.VG2.n28 ldo_brahim_0.ldo_brahim_pass_element2_0.VG2.n23 2.73109
R10745 ldo_brahim_0.ldo_brahim_pass_element2_0.VG2.n32 ldo_brahim_0.ldo_brahim_pass_element2_0.VG2.n31 2.72591
R10746 ldo_brahim_0.ldo_brahim_pass_element2_0.VG2.n27 ldo_brahim_0.ldo_brahim_pass_element2_0.VG2.n26 2.72591
R10747 ldo_brahim_0.ldo_brahim_pass_element2_0.VG2.n31 ldo_brahim_0.ldo_brahim_pass_element2_0.VG2.n30 2.72591
R10748 ldo_brahim_0.ldo_brahim_pass_element2_0.VG2.n28 ldo_brahim_0.ldo_brahim_pass_element2_0.VG2.n27 2.72591
R10749 ldo_brahim_0.ldo_brahim_pass_element2_0.VG2.n14 ldo_brahim_0.ldo_brahim_pass_element2_0.VG2.n7 2.72591
R10750 ldo_brahim_0.ldo_brahim_pass_element2_0.VG2.n20 ldo_brahim_0.ldo_brahim_pass_element2_0.VG2.n7 2.72591
R10751 ldo_brahim_0.ldo_brahim_pass_element2_0.VG2.t10 ldo_brahim_0.ldo_brahim_pass_element2_0.VG2.n13 2.55507
R10752 ldo_brahim_0.ldo_brahim_pass_element2_0.VG2.n14 ldo_brahim_0.ldo_brahim_pass_element2_0.VG2.n13 1.79484
R10753 ldo_brahim_0.ldo_brahim_pass_element2_0.VG2.n5 ldo_brahim_0.ldo_brahim_pass_element2_0.VG2.n4 1.69076
R10754 ldo_brahim_0.ldo_brahim_pass_element2_0.VG2.t10 ldo_brahim_0.ldo_brahim_pass_element2_0.VG2.n12 1.54037
R10755 ldo_brahim_0.ldo_brahim_pass_element2_0.VG2.n32 ldo_brahim_0.ldo_brahim_pass_element2_0.VG2.n12 1.43025
R10756 ldo_brahim_0.ldo_brahim_pass_element2_0.VG2.n37 ldo_brahim_0.ldo_brahim_pass_element2_0.VG2.t1 1.40178
R10757 ldo_brahim_0.ldo_brahim_pass_element2_0.VG2.n22 ldo_brahim_0.ldo_brahim_pass_element2_0.VG2.n20 1.22785
R10758 ldo_brahim_0.ldo_brahim_pass_element2_0.VG2.n22 ldo_brahim_0.ldo_brahim_pass_element2_0.VG2.n21 1.22785
R10759 ldo_brahim_0.ldo_brahim_pass_element2_0.VG2.n23 ldo_brahim_0.ldo_brahim_pass_element2_0.VG2.n12 0.860674
R10760 ldo_brahim_0.ldo_brahim_pass_element2_0.VG2.n23 ldo_brahim_0.ldo_brahim_pass_element2_0.VG2.n13 0.732173
R10761 ldo_brahim_0.ldo_brahim_pass_element2_0.VG2.n5 ldo_brahim_0.ldo_brahim_pass_element2_0.VG2.n0 0.230985
R10762 ldo_brahim_0.ldo_brahim_pass_element2_0.VG2 ldo_brahim_0.ldo_brahim_pass_element2_0.VG2.n34 0.226786
R10763 ldo_brahim_0.ldo_brahim_pass_element2_0.VG2.n4 ldo_brahim_0.ldo_brahim_pass_element2_0.VG2.t9 0.181458
R10764 ldo_brahim_0.ldo_brahim_pass_element2_0.VG2.n26 ldo_brahim_0.ldo_brahim_pass_element2_0.VG2.n10 0.157669
R10765 ldo_brahim_0.ldo_brahim_pass_element2_0.VG2.n25 ldo_brahim_0.ldo_brahim_pass_element2_0.VG2.n9 0.157669
R10766 ldo_brahim_0.ldo_brahim_pass_element2_0.VG2.n24 ldo_brahim_0.ldo_brahim_pass_element2_0.VG2.n8 0.157669
R10767 ldo_brahim_0.ldo_brahim_pass_element2_0.VG2.n27 ldo_brahim_0.ldo_brahim_pass_element2_0.VG2.n11 0.157665
R10768 ldo_brahim_0.ldo_brahim_pass_element2_0.VG2.n38 ldo_brahim_0.ldo_brahim_pass_element2_0.VG2.t2 0.145711
R10769 ldo_brahim_0.ldo_brahim_pass_element2_0.VG2.n2 ldo_brahim_0.ldo_brahim_pass_element2_0.VG2.t6 0.143064
R10770 ldo_brahim_0.ldo_brahim_pass_element2_0.VG2.n1 ldo_brahim_0.ldo_brahim_pass_element2_0.VG2.t7 0.142936
R10771 ldo_brahim_0.ldo_brahim_pass_element2_0.VG2.n3 ldo_brahim_0.ldo_brahim_pass_element2_0.VG2.t8 0.142343
R10772 ldo_brahim_0.ldo_brahim_pass_element2_0.VG2.n24 ldo_brahim_0.ldo_brahim_pass_element2_0.VG2.n17 0.140504
R10773 ldo_brahim_0.ldo_brahim_pass_element2_0.VG2.n39 ldo_brahim_0.ldo_brahim_pass_element2_0.VG2.t3 0.140452
R10774 ldo_brahim_0.ldo_brahim_pass_element2_0.VG2.n33 ldo_brahim_0.ldo_brahim_pass_element2_0.VG2.n32 0.106386
R10775 ldo_brahim_0.ldo_brahim_pass_element2_0.VG2.n26 ldo_brahim_0.ldo_brahim_pass_element2_0.VG2.n19 0.105741
R10776 ldo_brahim_0.ldo_brahim_pass_element2_0.VG2.n25 ldo_brahim_0.ldo_brahim_pass_element2_0.VG2.n18 0.105741
R10777 ldo_brahim_0.ldo_brahim_pass_element2_0.VG2.n28 ldo_brahim_0.ldo_brahim_pass_element2_0.VG2.n15 0.105741
R10778 ldo_brahim_0.ldo_brahim_pass_element2_0.VG2.n27 ldo_brahim_0.ldo_brahim_pass_element2_0.VG2.n16 0.105741
R10779 ldo_brahim_0.ldo_brahim_pass_element2_0.VG2.n33 ldo_brahim_0.ldo_brahim_pass_element2_0.VG2.n28 0.105129
R10780 ldo_brahim_0.ldo_brahim_pass_element2_0.VG2.n20 ldo_brahim_0.ldo_brahim_pass_element2_0.VG2.n19 0.104484
R10781 ldo_brahim_0.ldo_brahim_pass_element2_0.VG2.n21 ldo_brahim_0.ldo_brahim_pass_element2_0.VG2.n18 0.104484
R10782 ldo_brahim_0.ldo_brahim_pass_element2_0.VG2.n15 ldo_brahim_0.ldo_brahim_pass_element2_0.VG2.n14 0.104484
R10783 ldo_brahim_0.ldo_brahim_pass_element2_0.VG2.n16 ldo_brahim_0.ldo_brahim_pass_element2_0.VG2.n7 0.104484
R10784 ldo_brahim_0.ldo_brahim_pass_element2_0.VG2.n31 ldo_brahim_0.ldo_brahim_pass_element2_0.VG2.n11 0.0539305
R10785 ldo_brahim_0.ldo_brahim_pass_element2_0.VG2.n34 ldo_brahim_0.ldo_brahim_pass_element2_0.VG2.n7 0.0539286
R10786 ldo_brahim_0.ldo_brahim_pass_element2_0.VG2.n30 ldo_brahim_0.ldo_brahim_pass_element2_0.VG2.n10 0.0539262
R10787 ldo_brahim_0.ldo_brahim_pass_element2_0.VG2.n29 ldo_brahim_0.ldo_brahim_pass_element2_0.VG2.n9 0.0539262
R10788 ldo_brahim_0.ldo_brahim_pass_element2_0.VG2.n40 ldo_brahim_0.ldo_brahim_pass_element2_0.VG2 0.0445
R10789 ldo_brahim_0.ldo_brahim_pass_element2_0.VG2 ldo_brahim_0.ldo_brahim_pass_element2_0.VG2.n40 0.0335
R10790 VDD.n0 VDD.t0 19.8573
R10791 VDD.n29 VDD 12.9998
R10792 VDD.n80 VDD.n79 10.3938
R10793 VDD.n52 VDD.t15 4.74757
R10794 VDD.n58 VDD.t11 4.74757
R10795 VDD.n65 VDD.t6 4.74757
R10796 VDD.n50 VDD.t3 4.74757
R10797 VDD.n57 VDD.n56 4.62446
R10798 VDD.n53 VDD.n52 4.61534
R10799 VDD.n54 VDD.n53 4.61534
R10800 VDD.n55 VDD.n54 4.61534
R10801 VDD.n56 VDD.n55 4.61534
R10802 VDD.n59 VDD.n58 4.61534
R10803 VDD.n60 VDD.n59 4.61534
R10804 VDD.n61 VDD.n60 4.61534
R10805 VDD.n62 VDD.n61 4.61534
R10806 VDD.n63 VDD.n62 4.61534
R10807 VDD.n66 VDD.n65 4.61534
R10808 VDD.n67 VDD.n66 4.61534
R10809 VDD.n68 VDD.n67 4.61534
R10810 VDD.n69 VDD.n68 4.61534
R10811 VDD.n70 VDD.n69 4.61534
R10812 VDD.n75 VDD.n74 4.61534
R10813 VDD.n74 VDD.n73 4.61534
R10814 VDD.n73 VDD.n72 4.61534
R10815 VDD.n76 VDD.n75 4.20076
R10816 VDD.n51 VDD.n50 4.02193
R10817 VDD.n72 VDD.n71 3.09496
R10818 VDD.n64 VDD.n57 3.08583
R10819 VDD.n78 VDD.n77 2.29454
R10820 VDD.n80 VDD 2.289
R10821 VDD.n64 VDD.n63 2.06371
R10822 VDD.n71 VDD.n70 2.06371
R10823 VDD.n86 VDD.n85 1.86742
R10824 VDD.n81 VDD 1.45498
R10825 VDD.n79 VDD 1.31534
R10826 VDD.n77 VDD.n76 1.30391
R10827 VDD.n33 VDD.n28 1.29465
R10828 VDD.n84 VDD.n83 1.28621
R10829 VDD.n18 VDD.n17 1.28621
R10830 VDD.n47 VDD.n46 1.28621
R10831 VDD.n21 VDD.n20 1.28621
R10832 VDD.n42 VDD.n41 1.28621
R10833 VDD.n24 VDD.n23 1.28621
R10834 VDD.n37 VDD.n36 1.28621
R10835 VDD.n27 VDD.n26 1.28621
R10836 VDD.n32 VDD.n31 1.28621
R10837 VDD.n83 VDD.n82 1.28621
R10838 VDD.n49 VDD.n18 1.28621
R10839 VDD.n48 VDD.n47 1.28621
R10840 VDD.n20 VDD.n19 1.28621
R10841 VDD.n41 VDD.n40 1.28621
R10842 VDD.n39 VDD.n24 1.28621
R10843 VDD.n38 VDD.n37 1.28621
R10844 VDD.n26 VDD.n25 1.28621
R10845 VDD.n31 VDD.n30 1.28621
R10846 VDD.n29 VDD.n28 1.28621
R10847 VDD.n110 VDD.n109 1.28621
R10848 VDD.n2 VDD.n1 1.28621
R10849 VDD.n103 VDD.n102 1.28621
R10850 VDD.n101 VDD.n6 1.28621
R10851 VDD.n100 VDD.n99 1.28621
R10852 VDD.n8 VDD.n7 1.28621
R10853 VDD.n93 VDD.n92 1.28621
R10854 VDD.n91 VDD.n12 1.28621
R10855 VDD.n90 VDD.n89 1.28621
R10856 VDD.n14 VDD.n13 1.28621
R10857 VDD.n109 VDD.n108 1.28621
R10858 VDD.n3 VDD.n2 1.28621
R10859 VDD.n104 VDD.n103 1.28621
R10860 VDD.n6 VDD.n5 1.28621
R10861 VDD.n99 VDD.n98 1.28621
R10862 VDD.n9 VDD.n8 1.28621
R10863 VDD.n94 VDD.n93 1.28621
R10864 VDD.n12 VDD.n11 1.28621
R10865 VDD.n89 VDD.n88 1.28621
R10866 VDD.n15 VDD.n14 1.28621
R10867 VDD.n108 VDD.n107 1.28621
R10868 VDD.n106 VDD.n3 1.28621
R10869 VDD.n105 VDD.n104 1.28621
R10870 VDD.n5 VDD.n4 1.28621
R10871 VDD.n98 VDD.n97 1.28621
R10872 VDD.n96 VDD.n9 1.28621
R10873 VDD.n95 VDD.n94 1.28621
R10874 VDD.n11 VDD.n10 1.28621
R10875 VDD.n88 VDD.n87 1.28621
R10876 VDD.n86 VDD.n15 1.28621
R10877 VDD.n85 VDD.n84 1.28621
R10878 VDD.n17 VDD.n16 1.28621
R10879 VDD.n46 VDD.n45 1.28621
R10880 VDD.n44 VDD.n21 1.28621
R10881 VDD.n43 VDD.n42 1.28621
R10882 VDD.n23 VDD.n22 1.28621
R10883 VDD.n36 VDD.n35 1.28621
R10884 VDD.n34 VDD.n27 1.28621
R10885 VDD.n77 VDD.n51 1.25203
R10886 VDD.n71 VDD.n64 1.03175
R10887 VDD.t25 VDD.n51 0.91604
R10888 VDD.n34 VDD.n33 0.657492
R10889 VDD.n76 VDD.t25 0.630715
R10890 VDD.n81 VDD.n80 0.496359
R10891 VDD.n111 VDD.n0 0.402687
R10892 VDD.n107 VDD 0.3943
R10893 VDD.n57 VDD.t28 0.13273
R10894 VDD.n52 VDD.t1 0.13273
R10895 VDD.n53 VDD.t4 0.13273
R10896 VDD.n54 VDD.t16 0.13273
R10897 VDD.n55 VDD.t20 0.13273
R10898 VDD.n56 VDD.t26 0.13273
R10899 VDD.n58 VDD.t8 0.13273
R10900 VDD.n59 VDD.t13 0.13273
R10901 VDD.n60 VDD.t12 0.13273
R10902 VDD.n61 VDD.t14 0.13273
R10903 VDD.n62 VDD.t22 0.13273
R10904 VDD.n63 VDD.t2 0.13273
R10905 VDD.n65 VDD.t24 0.13273
R10906 VDD.n66 VDD.t27 0.13273
R10907 VDD.n67 VDD.t7 0.13273
R10908 VDD.n68 VDD.t10 0.13273
R10909 VDD.n69 VDD.t18 0.13273
R10910 VDD.n70 VDD.t21 0.13273
R10911 VDD.n75 VDD.t5 0.13273
R10912 VDD.n74 VDD.t9 0.13273
R10913 VDD.n73 VDD.t17 0.13273
R10914 VDD.n72 VDD.t19 0.13273
R10915 VDD.n50 VDD.t23 0.13273
R10916 VDD.n0 VDD 0.120812
R10917 VDD VDD.n111 0.0627719
R10918 VDD.n0 VDD 0.0507857
R10919 VDD.n78 VDD 0.0375526
R10920 VDD VDD.n78 0.0178115
R10921 VDD.n32 VDD.n27 0.0163797
R10922 VDD.n36 VDD.n27 0.0163797
R10923 VDD.n36 VDD.n23 0.0163797
R10924 VDD.n42 VDD.n23 0.0163797
R10925 VDD.n42 VDD.n21 0.0163797
R10926 VDD.n46 VDD.n21 0.0163797
R10927 VDD.n46 VDD.n17 0.0163797
R10928 VDD.n84 VDD.n17 0.0163797
R10929 VDD.n31 VDD.n28 0.0163797
R10930 VDD.n31 VDD.n26 0.0163797
R10931 VDD.n37 VDD.n26 0.0163797
R10932 VDD.n37 VDD.n24 0.0163797
R10933 VDD.n41 VDD.n24 0.0163797
R10934 VDD.n41 VDD.n20 0.0163797
R10935 VDD.n47 VDD.n20 0.0163797
R10936 VDD.n47 VDD.n18 0.0163797
R10937 VDD.n83 VDD.n18 0.0163797
R10938 VDD.n89 VDD.n14 0.0163797
R10939 VDD.n89 VDD.n12 0.0163797
R10940 VDD.n93 VDD.n12 0.0163797
R10941 VDD.n93 VDD.n8 0.0163797
R10942 VDD.n99 VDD.n8 0.0163797
R10943 VDD.n99 VDD.n6 0.0163797
R10944 VDD.n103 VDD.n6 0.0163797
R10945 VDD.n103 VDD.n2 0.0163797
R10946 VDD.n109 VDD.n2 0.0163797
R10947 VDD.n88 VDD.n15 0.0163797
R10948 VDD.n88 VDD.n11 0.0163797
R10949 VDD.n94 VDD.n11 0.0163797
R10950 VDD.n94 VDD.n9 0.0163797
R10951 VDD.n98 VDD.n9 0.0163797
R10952 VDD.n98 VDD.n5 0.0163797
R10953 VDD.n104 VDD.n5 0.0163797
R10954 VDD.n104 VDD.n3 0.0163797
R10955 VDD.n108 VDD.n3 0.0163797
R10956 VDD.n35 VDD.n34 0.01458
R10957 VDD.n35 VDD.n22 0.01458
R10958 VDD.n43 VDD.n22 0.01458
R10959 VDD.n44 VDD.n43 0.01458
R10960 VDD.n45 VDD.n44 0.01458
R10961 VDD.n45 VDD.n16 0.01458
R10962 VDD.n85 VDD.n16 0.01458
R10963 VDD.n87 VDD.n86 0.01458
R10964 VDD.n87 VDD.n10 0.01458
R10965 VDD.n95 VDD.n10 0.01458
R10966 VDD.n96 VDD.n95 0.01458
R10967 VDD.n97 VDD.n96 0.01458
R10968 VDD.n97 VDD.n4 0.01458
R10969 VDD.n105 VDD.n4 0.01458
R10970 VDD.n106 VDD.n105 0.01458
R10971 VDD.n107 VDD.n106 0.01458
R10972 VDD.n30 VDD.n29 0.0103324
R10973 VDD.n30 VDD.n25 0.0103324
R10974 VDD.n38 VDD.n25 0.0103324
R10975 VDD.n39 VDD.n38 0.0103324
R10976 VDD.n40 VDD.n39 0.0103324
R10977 VDD.n40 VDD.n19 0.0103324
R10978 VDD.n48 VDD.n19 0.0103324
R10979 VDD.n49 VDD.n48 0.0103324
R10980 VDD.n82 VDD.n49 0.0103324
R10981 VDD.n90 VDD.n13 0.0103324
R10982 VDD.n91 VDD.n90 0.0103324
R10983 VDD.n92 VDD.n91 0.0103324
R10984 VDD.n92 VDD.n7 0.0103324
R10985 VDD.n100 VDD.n7 0.0103324
R10986 VDD.n101 VDD.n100 0.0103324
R10987 VDD.n102 VDD.n101 0.0103324
R10988 VDD.n102 VDD.n1 0.0103324
R10989 VDD.n110 VDD.n1 0.0103324
R10990 VDD.n33 VDD.n32 0.00884841
R10991 VDD.n82 VDD.n81 0.0034702
R10992 VDD.n79 VDD.n13 0.0034702
R10993 VDD.n111 VDD.n110 0.0034702
R10994 a_5046_11016.t0 a_5046_11016.t1 30.559
R10995 a_5310_7848.t0 a_5310_7848.t1 30.559
R10996 a_11060_7350.t0 a_11060_7350.t1 30.2588
R10997 a_13388_7350.t0 a_13388_7350.t1 30.559
R10998 Vbg.n3 Vbg 28.6847
R10999 Vbg.n3 Vbg 28.4931
R11000 Vbg.n0 Vbg.t3 25.6551
R11001 Vbg.n0 Vbg.t2 21.5031
R11002 Vbg.n1 Vbg.t5 9.12029
R11003 Vbg.n1 Vbg.t4 7.63073
R11004 Vbg Vbg.n2 5.55733
R11005 Vbg.n5 Vbg 4.18486
R11006 Vbg.n2 Vbg.t0 3.66562
R11007 Vbg Vbg.n3 3.41747
R11008 Vbg Vbg.n0 2.8033
R11009 Vbg.n2 Vbg.t1 2.66498
R11010 Vbg Vbg.n1 2.4469
R11011 Vbg.n6 Vbg 2.14149
R11012 Vbg.n7 Vbg 1.96789
R11013 Vbg Vbg.n7 1.91679
R11014 Vbg.n6 Vbg.n5 0.782345
R11015 Vbg.n4 Vbg 0.610126
R11016 Vbg.n4 Vbg 0.441243
R11017 Vbg.n5 Vbg.n4 0.296311
R11018 Vbg.n7 Vbg.n6 0.0573571
R11019 ldo_brahim_0.ldo_brahim_opamp_2_stage_0/ldo_brahim_cs_0.VG.n4 ldo_brahim_0.ldo_brahim_opamp_2_stage_0/ldo_brahim_cs_0.VG 28.7403
R11020 ldo_brahim_0.ldo_brahim_opamp_2_stage_0/ldo_brahim_cs_0.VG.n7 ldo_brahim_0.ldo_brahim_opamp_2_stage_0/ldo_brahim_cs_0.VG.t3 25.2873
R11021 ldo_brahim_0.ldo_brahim_opamp_2_stage_0/ldo_brahim_cs_0.VG.n5 ldo_brahim_0.ldo_brahim_opamp_2_stage_0/ldo_brahim_cs_0.VG.t1 10.6431
R11022 ldo_brahim_0.ldo_brahim_opamp_2_stage_0/ldo_brahim_cs_0.VG.n4 ldo_brahim_0.ldo_brahim_opamp_2_stage_0/ldo_brahim_cs_0.VG.t6 8.98151
R11023 ldo_brahim_0.ldo_brahim_opamp_2_stage_0/ldo_brahim_cs_0.VG.n2 ldo_brahim_0.ldo_brahim_opamp_2_stage_0/ldo_brahim_cs_0.VG.n1 7.63431
R11024 ldo_brahim_0.ldo_brahim_opamp_2_stage_0/ldo_brahim_cs_0.VG.n3 ldo_brahim_0.ldo_brahim_opamp_2_stage_0/ldo_brahim_cs_0.VG.n2 6.05437
R11025 ldo_brahim_0.ldo_brahim_opamp_2_stage_0/ldo_brahim_cs_0.VG ldo_brahim_0.ldo_brahim_opamp_2_stage_0/ldo_brahim_cs_0.VG.n3 4.97475
R11026 ldo_brahim_0.ldo_brahim_opamp_2_stage_0/ldo_brahim_cs_0.VG ldo_brahim_0.ldo_brahim_opamp_2_stage_0/ldo_brahim_cs_0.VG.n7 4.50083
R11027 ldo_brahim_0.ldo_brahim_opamp_2_stage_0/ldo_brahim_cs_0.VG ldo_brahim_0.ldo_brahim_opamp_2_stage_0/ldo_brahim_cs_0.VG.n5 4.26738
R11028 ldo_brahim_0.ldo_brahim_opamp_2_stage_0/ldo_brahim_cs_0.VG.n2 ldo_brahim_0.ldo_brahim_opamp_2_stage_0/ldo_brahim_cs_0.VG.n0 3.08762
R11029 ldo_brahim_0.ldo_brahim_opamp_2_stage_0/ldo_brahim_cs_0.VG.n6 ldo_brahim_0.ldo_brahim_opamp_2_stage_0/ldo_brahim_cs_0.VG.n4 2.4716
R11030 ldo_brahim_0.ldo_brahim_opamp_2_stage_0/ldo_brahim_cs_0.VG.n3 ldo_brahim_0.ldo_brahim_opamp_2_stage_0/ldo_brahim_cs_0.VG.t5 1.6218
R11031 ldo_brahim_0.ldo_brahim_opamp_2_stage_0/ldo_brahim_cs_0.VG.n5 ldo_brahim_0.ldo_brahim_opamp_2_stage_0/ldo_brahim_cs_0.VG.t0 0.845117
R11032 ldo_brahim_0.ldo_brahim_opamp_2_stage_0/ldo_brahim_cs_0.VG ldo_brahim_0.ldo_brahim_opamp_2_stage_0/ldo_brahim_cs_0.VG.n6 0.244035
R11033 ldo_brahim_0.ldo_brahim_opamp_2_stage_0/ldo_brahim_cs_0.VG.n7 ldo_brahim_0.ldo_brahim_opamp_2_stage_0/ldo_brahim_cs_0.VG.t2 0.140696
R11034 ldo_brahim_0.ldo_brahim_opamp_2_stage_0/ldo_brahim_cs_0.VG.n6 ldo_brahim_0.ldo_brahim_opamp_2_stage_0/ldo_brahim_cs_0.VG 0.0455233
R11035 ldo_brahim_0.ldo_brahim_opamp_2_stage_0/ldo_brahim_cs_0.VG.n0 ldo_brahim_0.ldo_brahim_opamp_2_stage_0/ldo_brahim_cs_0.VG.t7 0.002295
R11036 ldo_brahim_0.ldo_brahim_opamp_2_stage_0/ldo_brahim_cs_0.VG.t6 ldo_brahim_0.ldo_brahim_opamp_2_stage_0/ldo_brahim_cs_0.VG.t4 0.00215986
R11037 ldo_brahim_0.ldo_brahim_opamp_2_stage_0/ldo_brahim_cs_0.VG.t8 ldo_brahim_0.ldo_brahim_opamp_2_stage_0/ldo_brahim_cs_0.VG.n0 0.00170495
R11038 ldo_brahim_0.ldo_brahim_opamp_2_stage_0/ldo_brahim_cs_0.VG.n1 ldo_brahim_0.ldo_brahim_opamp_2_stage_0/ldo_brahim_cs_0.VG.t5 0.001
R11039 ldo_brahim_0.ldo_brahim_opamp_2_stage_0/ldo_brahim_cs_0.VG.n1 ldo_brahim_0.ldo_brahim_opamp_2_stage_0/ldo_brahim_cs_0.VG.t8 0.001
R11040 beta_multiplier_0.beta_multiplier_startup_0.beta_multiplier_startup_mirror_0.VS2.n5 beta_multiplier_0.beta_multiplier_startup_0.beta_multiplier_startup_mirror_0.VS2.t4 8.96891
R11041 beta_multiplier_0.beta_multiplier_startup_0.beta_multiplier_startup_mirror_0.VS2.n4 beta_multiplier_0.beta_multiplier_startup_0.beta_multiplier_startup_mirror_0.VS2.t2 8.57981
R11042 beta_multiplier_0.beta_multiplier_startup_0.beta_multiplier_startup_mirror_0.VS2.n5 beta_multiplier_0.beta_multiplier_startup_0.beta_multiplier_startup_mirror_0.VS2.n4 3.75938
R11043 beta_multiplier_0.beta_multiplier_startup_0.beta_multiplier_startup_mirror_0.VS2.n1 beta_multiplier_0.beta_multiplier_startup_0.beta_multiplier_startup_mirror_0.VS2.n0 2.58951
R11044 beta_multiplier_0.beta_multiplier_startup_0.beta_multiplier_startup_mirror_0.VS2.n1 beta_multiplier_0.beta_multiplier_startup_0.beta_multiplier_startup_mirror_0.VS2.t1 2.37854
R11045 beta_multiplier_0.beta_multiplier_startup_0.beta_multiplier_startup_mirror_0.VS2.n2 beta_multiplier_0.beta_multiplier_startup_0.beta_multiplier_startup_mirror_0.VS2.t0 1.51124
R11046 beta_multiplier_0.beta_multiplier_startup_0.beta_multiplier_startup_mirror_0.VS2.n3 beta_multiplier_0.beta_multiplier_startup_0.beta_multiplier_startup_mirror_0.VS2.n2 1.49385
R11047 beta_multiplier_0.beta_multiplier_startup_0.beta_multiplier_startup_mirror_0.VS2.n4 beta_multiplier_0.beta_multiplier_startup_0.beta_multiplier_startup_mirror_0.VS2.n3 1.27862
R11048 beta_multiplier_0.beta_multiplier_startup_0.beta_multiplier_startup_mirror_0.VS2.t2 beta_multiplier_0.beta_multiplier_startup_0.beta_multiplier_startup_mirror_0.VS2.n3 1.02635
R11049 beta_multiplier_0.beta_multiplier_startup_0.beta_multiplier_startup_mirror_0.VS2.n6 beta_multiplier_0.beta_multiplier_startup_0.beta_multiplier_startup_mirror_0.VS2 0.104029
R11050 beta_multiplier_0.beta_multiplier_startup_0.beta_multiplier_startup_mirror_0.VS2.n2 beta_multiplier_0.beta_multiplier_startup_0.beta_multiplier_startup_mirror_0.VS2.n1 0.10315
R11051 beta_multiplier_0.beta_multiplier_startup_0.beta_multiplier_startup_mirror_0.VS2.n6 beta_multiplier_0.beta_multiplier_startup_0.beta_multiplier_startup_mirror_0.VS2.n5 0.035585
R11052 beta_multiplier_0.beta_multiplier_startup_0.beta_multiplier_startup_mirror_0.VS2 beta_multiplier_0.beta_multiplier_startup_0.beta_multiplier_startup_mirror_0.VS2.n6 0.0102778
R11053 beta_multiplier_0.beta_multiplier_startup_0.beta_multiplier_startup_mirror_0.VS2.n0 beta_multiplier_0.beta_multiplier_startup_0.beta_multiplier_startup_mirror_0.VS2.t0 0.00208473
R11054 beta_multiplier_0.beta_multiplier_startup_0.beta_multiplier_startup_mirror_0.VS2.n0 beta_multiplier_0.beta_multiplier_startup_0.beta_multiplier_startup_mirror_0.VS2.t3 0.00191519
R11055 a_13630_7878.t0 a_13630_7878.t1 30.559
R11056 a_15716_7614.t0 a_15716_7614.t1 30.559
R11057 a_15716_8142.t0 a_15716_8142.t1 30.559
R11058 beta_multiplier_0.beta_multiplier_mirror_0.VN.n5 beta_multiplier_0.beta_multiplier_mirror_0.VN.n4 13.1394
R11059 beta_multiplier_0.beta_multiplier_mirror_0.VN.n1 beta_multiplier_0.beta_multiplier_mirror_0.VN.n0 10.0247
R11060 beta_multiplier_0.beta_multiplier_mirror_0.VN.n0 beta_multiplier_0.beta_multiplier_mirror_0.VN.t1 8.6191
R11061 beta_multiplier_0.beta_multiplier_mirror_0.VN.n3 beta_multiplier_0.beta_multiplier_mirror_0.VN.t4 7.501
R11062 beta_multiplier_0.beta_multiplier_mirror_0.VN.n4 beta_multiplier_0.beta_multiplier_mirror_0.VN.t6 7.501
R11063 beta_multiplier_0.beta_multiplier_mirror_0.VN.n4 beta_multiplier_0.beta_multiplier_mirror_0.VN.t3 6.69067
R11064 beta_multiplier_0.beta_multiplier_mirror_0.VN.n2 beta_multiplier_0.beta_multiplier_mirror_0.VN.t5 5.36913
R11065 beta_multiplier_0.beta_multiplier_mirror_0.VN beta_multiplier_0.beta_multiplier_mirror_0.VN.n5 5.1529
R11066 beta_multiplier_0.beta_multiplier_mirror_0.VN beta_multiplier_0.beta_multiplier_mirror_0.VN.n1 4.99367
R11067 beta_multiplier_0.beta_multiplier_mirror_0.VN.n5 beta_multiplier_0.beta_multiplier_mirror_0.VN.n3 4.79852
R11068 beta_multiplier_0.beta_multiplier_mirror_0.VN.n2 beta_multiplier_0.beta_multiplier_mirror_0.VN.t2 2.40491
R11069 beta_multiplier_0.beta_multiplier_mirror_0.VN.n0 beta_multiplier_0.beta_multiplier_mirror_0.VN.t1 2.25581
R11070 beta_multiplier_0.beta_multiplier_mirror_0.VN.n3 beta_multiplier_0.beta_multiplier_mirror_0.VN.n2 1.32205
R11071 beta_multiplier_0.beta_multiplier_mirror_0.VN.n1 beta_multiplier_0.beta_multiplier_mirror_0.VN.t0 0.868073
R11072 a_5183_1757.n59 a_5183_1757.t2 20.9154
R11073 a_5183_1757.n60 a_5183_1757.n59 1.51654
R11074 a_5183_1757.n26 a_5183_1757.n21 1.51039
R11075 a_5183_1757.n58 a_5183_1757.n2 1.5005
R11076 a_5183_1757.n57 a_5183_1757.n56 1.5005
R11077 a_5183_1757.n4 a_5183_1757.n3 1.5005
R11078 a_5183_1757.n49 a_5183_1757.n48 1.5005
R11079 a_5183_1757.n47 a_5183_1757.n8 1.5005
R11080 a_5183_1757.n46 a_5183_1757.n45 1.5005
R11081 a_5183_1757.n10 a_5183_1757.n9 1.5005
R11082 a_5183_1757.n39 a_5183_1757.n38 1.5005
R11083 a_5183_1757.n37 a_5183_1757.n14 1.5005
R11084 a_5183_1757.n36 a_5183_1757.n35 1.5005
R11085 a_5183_1757.n16 a_5183_1757.n15 1.5005
R11086 a_5183_1757.n29 a_5183_1757.n28 1.5005
R11087 a_5183_1757.n27 a_5183_1757.n20 1.5005
R11088 a_5183_1757.n61 a_5183_1757.n60 1.5005
R11089 a_5183_1757.n2 a_5183_1757.n1 1.5005
R11090 a_5183_1757.n56 a_5183_1757.n55 1.5005
R11091 a_5183_1757.n5 a_5183_1757.n4 1.5005
R11092 a_5183_1757.n50 a_5183_1757.n49 1.5005
R11093 a_5183_1757.n8 a_5183_1757.n7 1.5005
R11094 a_5183_1757.n45 a_5183_1757.n44 1.5005
R11095 a_5183_1757.n11 a_5183_1757.n10 1.5005
R11096 a_5183_1757.n40 a_5183_1757.n39 1.5005
R11097 a_5183_1757.n14 a_5183_1757.n13 1.5005
R11098 a_5183_1757.n35 a_5183_1757.n34 1.5005
R11099 a_5183_1757.n17 a_5183_1757.n16 1.5005
R11100 a_5183_1757.n30 a_5183_1757.n29 1.5005
R11101 a_5183_1757.n20 a_5183_1757.n19 1.5005
R11102 a_5183_1757.n25 a_5183_1757.n24 1.5005
R11103 a_5183_1757.n62 a_5183_1757.n61 1.5005
R11104 a_5183_1757.n1 a_5183_1757.n0 1.5005
R11105 a_5183_1757.n55 a_5183_1757.n54 1.5005
R11106 a_5183_1757.n53 a_5183_1757.n5 1.5005
R11107 a_5183_1757.n51 a_5183_1757.n50 1.5005
R11108 a_5183_1757.n7 a_5183_1757.n6 1.5005
R11109 a_5183_1757.n44 a_5183_1757.n43 1.5005
R11110 a_5183_1757.n42 a_5183_1757.n11 1.5005
R11111 a_5183_1757.n41 a_5183_1757.n40 1.5005
R11112 a_5183_1757.n13 a_5183_1757.n12 1.5005
R11113 a_5183_1757.n34 a_5183_1757.n33 1.5005
R11114 a_5183_1757.n32 a_5183_1757.n17 1.5005
R11115 a_5183_1757.n31 a_5183_1757.n30 1.5005
R11116 a_5183_1757.n19 a_5183_1757.n18 1.5005
R11117 a_5183_1757.n24 a_5183_1757.n23 1.5005
R11118 a_5183_1757.n22 a_5183_1757.n21 1.5005
R11119 a_5183_1757.n27 a_5183_1757.n26 0.769773
R11120 a_5183_1757.n62 a_5183_1757.t1 0.120646
R11121 a_5183_1757.n28 a_5183_1757.n27 0.0192733
R11122 a_5183_1757.n28 a_5183_1757.n15 0.0192733
R11123 a_5183_1757.n36 a_5183_1757.n15 0.0192733
R11124 a_5183_1757.n37 a_5183_1757.n36 0.0192733
R11125 a_5183_1757.n38 a_5183_1757.n37 0.0192733
R11126 a_5183_1757.n38 a_5183_1757.n9 0.0192733
R11127 a_5183_1757.n46 a_5183_1757.n9 0.0192733
R11128 a_5183_1757.n47 a_5183_1757.n46 0.0192733
R11129 a_5183_1757.n48 a_5183_1757.n47 0.0192733
R11130 a_5183_1757.n48 a_5183_1757.n3 0.0192733
R11131 a_5183_1757.n57 a_5183_1757.n3 0.0192733
R11132 a_5183_1757.n58 a_5183_1757.n57 0.0192733
R11133 a_5183_1757.n25 a_5183_1757.n20 0.0192733
R11134 a_5183_1757.n29 a_5183_1757.n20 0.0192733
R11135 a_5183_1757.n29 a_5183_1757.n16 0.0192733
R11136 a_5183_1757.n35 a_5183_1757.n16 0.0192733
R11137 a_5183_1757.n35 a_5183_1757.n14 0.0192733
R11138 a_5183_1757.n39 a_5183_1757.n14 0.0192733
R11139 a_5183_1757.n39 a_5183_1757.n10 0.0192733
R11140 a_5183_1757.n45 a_5183_1757.n10 0.0192733
R11141 a_5183_1757.n45 a_5183_1757.n8 0.0192733
R11142 a_5183_1757.n49 a_5183_1757.n8 0.0192733
R11143 a_5183_1757.n49 a_5183_1757.n4 0.0192733
R11144 a_5183_1757.n56 a_5183_1757.n4 0.0192733
R11145 a_5183_1757.n56 a_5183_1757.n2 0.0192733
R11146 a_5183_1757.n60 a_5183_1757.n2 0.0192733
R11147 a_5183_1757.n24 a_5183_1757.n21 0.0192733
R11148 a_5183_1757.n24 a_5183_1757.n19 0.0192733
R11149 a_5183_1757.n30 a_5183_1757.n19 0.0192733
R11150 a_5183_1757.n30 a_5183_1757.n17 0.0192733
R11151 a_5183_1757.n34 a_5183_1757.n17 0.0192733
R11152 a_5183_1757.n34 a_5183_1757.n13 0.0192733
R11153 a_5183_1757.n40 a_5183_1757.n13 0.0192733
R11154 a_5183_1757.n40 a_5183_1757.n11 0.0192733
R11155 a_5183_1757.n44 a_5183_1757.n11 0.0192733
R11156 a_5183_1757.n44 a_5183_1757.n7 0.0192733
R11157 a_5183_1757.n50 a_5183_1757.n7 0.0192733
R11158 a_5183_1757.n50 a_5183_1757.n5 0.0192733
R11159 a_5183_1757.n55 a_5183_1757.n5 0.0192733
R11160 a_5183_1757.n55 a_5183_1757.n1 0.0192733
R11161 a_5183_1757.n61 a_5183_1757.n1 0.0192733
R11162 a_5183_1757.n26 a_5183_1757.n25 0.0102706
R11163 a_5183_1757.n22 a_5183_1757.t1 0.00777292
R11164 a_5183_1757.n59 a_5183_1757.n58 0.00323778
R11165 a_5183_1757.t1 a_5183_1757.t0 0.00128797
R11166 a_5183_1757.n23 a_5183_1757.n22 0.00125645
R11167 a_5183_1757.n23 a_5183_1757.n18 0.00125645
R11168 a_5183_1757.n31 a_5183_1757.n18 0.00125645
R11169 a_5183_1757.n32 a_5183_1757.n31 0.00125645
R11170 a_5183_1757.n33 a_5183_1757.n32 0.00125645
R11171 a_5183_1757.n33 a_5183_1757.n12 0.00125645
R11172 a_5183_1757.n41 a_5183_1757.n12 0.00125645
R11173 a_5183_1757.n42 a_5183_1757.n41 0.00125645
R11174 a_5183_1757.n43 a_5183_1757.n42 0.00125645
R11175 a_5183_1757.n43 a_5183_1757.n6 0.00125645
R11176 a_5183_1757.n51 a_5183_1757.n6 0.00125645
R11177 a_5183_1757.n54 a_5183_1757.n53 0.00125645
R11178 a_5183_1757.n54 a_5183_1757.n0 0.00125645
R11179 a_5183_1757.n62 a_5183_1757.n0 0.00125645
R11180 a_5183_1757.n53 a_5183_1757.n52 0.0010043
R11181 a_5183_1757.n52 a_5183_1757.n51 0.000752149
R11182 a_2835_2443.t0 a_2835_2443.t1 30.358
R11183 a_4959_2576.t0 a_4959_2576.t1 30.358
R11184 a_15958_7878.t0 a_15958_7878.t1 30.559
R11185 a_18044_7614.t0 a_18044_7614.t1 30.559
R11186 bgr_djalal_0.bgr_djalal_ota_1_stage_0.VN.n0 bgr_djalal_0.bgr_djalal_ota_1_stage_0.VN.t0 25.1951
R11187 bgr_djalal_0.bgr_djalal_ota_1_stage_0.VN.n0 bgr_djalal_0.bgr_djalal_ota_1_stage_0.VN.t1 24.4382
R11188 bgr_djalal_0.bgr_djalal_ota_1_stage_0.VN.n3 bgr_djalal_0.bgr_djalal_ota_1_stage_0.VN 19.5412
R11189 bgr_djalal_0.bgr_djalal_ota_1_stage_0.VN bgr_djalal_0.bgr_djalal_ota_1_stage_0.VN.n5 18.1533
R11190 bgr_djalal_0.bgr_djalal_ota_1_stage_0.VN bgr_djalal_0.bgr_djalal_ota_1_stage_0.VN.t5 8.45277
R11191 bgr_djalal_0.bgr_djalal_ota_1_stage_0.VN bgr_djalal_0.bgr_djalal_ota_1_stage_0.VN.n4 7.9711
R11192 bgr_djalal_0.bgr_djalal_ota_1_stage_0.VN.n4 bgr_djalal_0.bgr_djalal_ota_1_stage_0.VN.t4 7.80157
R11193 bgr_djalal_0.bgr_djalal_ota_1_stage_0.VN.n2 bgr_djalal_0.bgr_djalal_ota_1_stage_0.VN.n1 7.19386
R11194 bgr_djalal_0.bgr_djalal_ota_1_stage_0.VN.n5 bgr_djalal_0.bgr_djalal_ota_1_stage_0.VN 6.6961
R11195 bgr_djalal_0.bgr_djalal_ota_1_stage_0.VN.n5 bgr_djalal_0.bgr_djalal_ota_1_stage_0.VN.n3 6.02434
R11196 bgr_djalal_0.bgr_djalal_ota_1_stage_0.VN.n1 bgr_djalal_0.bgr_djalal_ota_1_stage_0.VN.t2 4.34612
R11197 bgr_djalal_0.bgr_djalal_ota_1_stage_0.VN.n4 bgr_djalal_0.bgr_djalal_ota_1_stage_0.VN.t6 4.09559
R11198 bgr_djalal_0.bgr_djalal_ota_1_stage_0.VN.n3 bgr_djalal_0.bgr_djalal_ota_1_stage_0.VN.n2 4.02714
R11199 bgr_djalal_0.bgr_djalal_ota_1_stage_0.VN bgr_djalal_0.bgr_djalal_ota_1_stage_0.VN.n0 3.9649
R11200 bgr_djalal_0.bgr_djalal_ota_1_stage_0.VN.n1 bgr_djalal_0.bgr_djalal_ota_1_stage_0.VN.t3 0.349631
R11201 bgr_djalal_0.bgr_djalal_ota_1_stage_0.VN.n2 bgr_djalal_0.bgr_djalal_ota_1_stage_0.VN 0.0222284
R11202 bgr_djalal_0.bgr_djalal_ota_1_stage_0.bgr_djalal_ota_tail_0.tail.n28 bgr_djalal_0.bgr_djalal_ota_1_stage_0.bgr_djalal_ota_tail_0.tail.t6 17.0005
R11203 bgr_djalal_0.bgr_djalal_ota_1_stage_0.bgr_djalal_ota_tail_0.tail.t0 bgr_djalal_0.bgr_djalal_ota_1_stage_0.bgr_djalal_ota_tail_0.tail.n26 17.0005
R11204 bgr_djalal_0.bgr_djalal_ota_1_stage_0.bgr_djalal_ota_tail_0.tail.n6 bgr_djalal_0.bgr_djalal_ota_1_stage_0.bgr_djalal_ota_tail_0.tail.t6 8.49558
R11205 bgr_djalal_0.bgr_djalal_ota_1_stage_0.bgr_djalal_ota_tail_0.tail.n8 bgr_djalal_0.bgr_djalal_ota_1_stage_0.bgr_djalal_ota_tail_0.tail.t6 8.49558
R11206 bgr_djalal_0.bgr_djalal_ota_1_stage_0.bgr_djalal_ota_tail_0.tail.n10 bgr_djalal_0.bgr_djalal_ota_1_stage_0.bgr_djalal_ota_tail_0.tail.t6 8.49558
R11207 bgr_djalal_0.bgr_djalal_ota_1_stage_0.bgr_djalal_ota_tail_0.tail.n12 bgr_djalal_0.bgr_djalal_ota_1_stage_0.bgr_djalal_ota_tail_0.tail.t6 8.49558
R11208 bgr_djalal_0.bgr_djalal_ota_1_stage_0.bgr_djalal_ota_tail_0.tail.n16 bgr_djalal_0.bgr_djalal_ota_1_stage_0.bgr_djalal_ota_tail_0.tail.t6 8.49558
R11209 bgr_djalal_0.bgr_djalal_ota_1_stage_0.bgr_djalal_ota_tail_0.tail.n20 bgr_djalal_0.bgr_djalal_ota_1_stage_0.bgr_djalal_ota_tail_0.tail.t6 8.49558
R11210 bgr_djalal_0.bgr_djalal_ota_1_stage_0.bgr_djalal_ota_tail_0.tail.n22 bgr_djalal_0.bgr_djalal_ota_1_stage_0.bgr_djalal_ota_tail_0.tail.t6 8.49558
R11211 bgr_djalal_0.bgr_djalal_ota_1_stage_0.bgr_djalal_ota_tail_0.tail.n24 bgr_djalal_0.bgr_djalal_ota_1_stage_0.bgr_djalal_ota_tail_0.tail.t6 8.49558
R11212 bgr_djalal_0.bgr_djalal_ota_1_stage_0.bgr_djalal_ota_tail_0.tail.n27 bgr_djalal_0.bgr_djalal_ota_1_stage_0.bgr_djalal_ota_tail_0.tail.t0 8.49558
R11213 bgr_djalal_0.bgr_djalal_ota_1_stage_0.bgr_djalal_ota_tail_0.tail.t0 bgr_djalal_0.bgr_djalal_ota_1_stage_0.bgr_djalal_ota_tail_0.tail.n5 8.49558
R11214 bgr_djalal_0.bgr_djalal_ota_1_stage_0.bgr_djalal_ota_tail_0.tail.t0 bgr_djalal_0.bgr_djalal_ota_1_stage_0.bgr_djalal_ota_tail_0.tail.n9 8.49558
R11215 bgr_djalal_0.bgr_djalal_ota_1_stage_0.bgr_djalal_ota_tail_0.tail.t0 bgr_djalal_0.bgr_djalal_ota_1_stage_0.bgr_djalal_ota_tail_0.tail.n13 8.49558
R11216 bgr_djalal_0.bgr_djalal_ota_1_stage_0.bgr_djalal_ota_tail_0.tail.t0 bgr_djalal_0.bgr_djalal_ota_1_stage_0.bgr_djalal_ota_tail_0.tail.n15 8.49558
R11217 bgr_djalal_0.bgr_djalal_ota_1_stage_0.bgr_djalal_ota_tail_0.tail.t0 bgr_djalal_0.bgr_djalal_ota_1_stage_0.bgr_djalal_ota_tail_0.tail.n17 8.49558
R11218 bgr_djalal_0.bgr_djalal_ota_1_stage_0.bgr_djalal_ota_tail_0.tail.t0 bgr_djalal_0.bgr_djalal_ota_1_stage_0.bgr_djalal_ota_tail_0.tail.n19 8.49558
R11219 bgr_djalal_0.bgr_djalal_ota_1_stage_0.bgr_djalal_ota_tail_0.tail.t0 bgr_djalal_0.bgr_djalal_ota_1_stage_0.bgr_djalal_ota_tail_0.tail.n23 8.49558
R11220 bgr_djalal_0.bgr_djalal_ota_1_stage_0.bgr_djalal_ota_tail_0.tail.n4 bgr_djalal_0.bgr_djalal_ota_1_stage_0.bgr_djalal_ota_tail_0.tail.t6 8.4955
R11221 bgr_djalal_0.bgr_djalal_ota_1_stage_0.bgr_djalal_ota_tail_0.tail.n14 bgr_djalal_0.bgr_djalal_ota_1_stage_0.bgr_djalal_ota_tail_0.tail.t6 8.4955
R11222 bgr_djalal_0.bgr_djalal_ota_1_stage_0.bgr_djalal_ota_tail_0.tail.n18 bgr_djalal_0.bgr_djalal_ota_1_stage_0.bgr_djalal_ota_tail_0.tail.t6 8.4955
R11223 bgr_djalal_0.bgr_djalal_ota_1_stage_0.bgr_djalal_ota_tail_0.tail.t0 bgr_djalal_0.bgr_djalal_ota_1_stage_0.bgr_djalal_ota_tail_0.tail.n7 8.4955
R11224 bgr_djalal_0.bgr_djalal_ota_1_stage_0.bgr_djalal_ota_tail_0.tail.t0 bgr_djalal_0.bgr_djalal_ota_1_stage_0.bgr_djalal_ota_tail_0.tail.n11 8.4955
R11225 bgr_djalal_0.bgr_djalal_ota_1_stage_0.bgr_djalal_ota_tail_0.tail.t0 bgr_djalal_0.bgr_djalal_ota_1_stage_0.bgr_djalal_ota_tail_0.tail.n21 8.4955
R11226 bgr_djalal_0.bgr_djalal_ota_1_stage_0.bgr_djalal_ota_tail_0.tail.n0 bgr_djalal_0.bgr_djalal_ota_1_stage_0.bgr_djalal_ota_tail_0.tail.t3 5.40431
R11227 bgr_djalal_0.bgr_djalal_ota_1_stage_0.bgr_djalal_ota_tail_0.tail.n1 bgr_djalal_0.bgr_djalal_ota_1_stage_0.bgr_djalal_ota_tail_0.tail.t2 4.45491
R11228 bgr_djalal_0.bgr_djalal_ota_1_stage_0.bgr_djalal_ota_tail_0.tail.t0 bgr_djalal_0.bgr_djalal_ota_1_stage_0.bgr_djalal_ota_tail_0.tail.n3 2.86553
R11229 bgr_djalal_0.bgr_djalal_ota_1_stage_0.bgr_djalal_ota_tail_0.tail.t6 bgr_djalal_0.bgr_djalal_ota_1_stage_0.bgr_djalal_ota_tail_0.tail.n3 2.8655
R11230 bgr_djalal_0.bgr_djalal_ota_1_stage_0.bgr_djalal_ota_tail_0.tail.n2 bgr_djalal_0.bgr_djalal_ota_1_stage_0.bgr_djalal_ota_tail_0.tail.n1 2.2505
R11231 bgr_djalal_0.bgr_djalal_ota_1_stage_0.bgr_djalal_ota_tail_0.tail.n0 bgr_djalal_0.bgr_djalal_ota_1_stage_0.bgr_djalal_ota_tail_0.tail.t1 2.13181
R11232 bgr_djalal_0.bgr_djalal_ota_1_stage_0.bgr_djalal_ota_tail_0.tail bgr_djalal_0.bgr_djalal_ota_1_stage_0.bgr_djalal_ota_tail_0.tail.n29 1.26495
R11233 bgr_djalal_0.bgr_djalal_ota_1_stage_0.bgr_djalal_ota_tail_0.tail.n1 bgr_djalal_0.bgr_djalal_ota_1_stage_0.bgr_djalal_ota_tail_0.tail.n0 0.701095
R11234 bgr_djalal_0.bgr_djalal_ota_1_stage_0.bgr_djalal_ota_tail_0.tail.n25 bgr_djalal_0.bgr_djalal_ota_1_stage_0.bgr_djalal_ota_tail_0.tail.t4 0.592113
R11235 bgr_djalal_0.bgr_djalal_ota_1_stage_0.bgr_djalal_ota_tail_0.tail.n25 bgr_djalal_0.bgr_djalal_ota_1_stage_0.bgr_djalal_ota_tail_0.tail.t5 0.592069
R11236 bgr_djalal_0.bgr_djalal_ota_1_stage_0.bgr_djalal_ota_tail_0.tail.n2 bgr_djalal_0.bgr_djalal_ota_1_stage_0.bgr_djalal_ota_tail_0.tail 0.4757
R11237 bgr_djalal_0.bgr_djalal_ota_1_stage_0.bgr_djalal_ota_tail_0.tail.n26 bgr_djalal_0.bgr_djalal_ota_1_stage_0.bgr_djalal_ota_tail_0.tail.n25 0.282788
R11238 bgr_djalal_0.bgr_djalal_ota_1_stage_0.bgr_djalal_ota_tail_0.tail.n2 bgr_djalal_0.bgr_djalal_ota_1_stage_0.bgr_djalal_ota_tail_0.tail 0.2051
R11239 bgr_djalal_0.bgr_djalal_ota_1_stage_0.bgr_djalal_ota_tail_0.tail.n29 bgr_djalal_0.bgr_djalal_ota_1_stage_0.bgr_djalal_ota_tail_0.tail.n3 0.0472996
R11240 bgr_djalal_0.bgr_djalal_ota_1_stage_0.bgr_djalal_ota_tail_0.tail.n27 bgr_djalal_0.bgr_djalal_ota_1_stage_0.bgr_djalal_ota_tail_0.tail.n4 0.0233288
R11241 bgr_djalal_0.bgr_djalal_ota_1_stage_0.bgr_djalal_ota_tail_0.tail.n8 bgr_djalal_0.bgr_djalal_ota_1_stage_0.bgr_djalal_ota_tail_0.tail.n7 0.0233288
R11242 bgr_djalal_0.bgr_djalal_ota_1_stage_0.bgr_djalal_ota_tail_0.tail.n12 bgr_djalal_0.bgr_djalal_ota_1_stage_0.bgr_djalal_ota_tail_0.tail.n11 0.0233288
R11243 bgr_djalal_0.bgr_djalal_ota_1_stage_0.bgr_djalal_ota_tail_0.tail.n14 bgr_djalal_0.bgr_djalal_ota_1_stage_0.bgr_djalal_ota_tail_0.tail.n13 0.0233288
R11244 bgr_djalal_0.bgr_djalal_ota_1_stage_0.bgr_djalal_ota_tail_0.tail.n18 bgr_djalal_0.bgr_djalal_ota_1_stage_0.bgr_djalal_ota_tail_0.tail.n17 0.0233288
R11245 bgr_djalal_0.bgr_djalal_ota_1_stage_0.bgr_djalal_ota_tail_0.tail.n22 bgr_djalal_0.bgr_djalal_ota_1_stage_0.bgr_djalal_ota_tail_0.tail.n21 0.0233288
R11246 bgr_djalal_0.bgr_djalal_ota_1_stage_0.bgr_djalal_ota_tail_0.tail.n5 bgr_djalal_0.bgr_djalal_ota_1_stage_0.bgr_djalal_ota_tail_0.tail.n4 0.0233288
R11247 bgr_djalal_0.bgr_djalal_ota_1_stage_0.bgr_djalal_ota_tail_0.tail.n7 bgr_djalal_0.bgr_djalal_ota_1_stage_0.bgr_djalal_ota_tail_0.tail.n6 0.0233288
R11248 bgr_djalal_0.bgr_djalal_ota_1_stage_0.bgr_djalal_ota_tail_0.tail.n11 bgr_djalal_0.bgr_djalal_ota_1_stage_0.bgr_djalal_ota_tail_0.tail.n10 0.0233288
R11249 bgr_djalal_0.bgr_djalal_ota_1_stage_0.bgr_djalal_ota_tail_0.tail.n15 bgr_djalal_0.bgr_djalal_ota_1_stage_0.bgr_djalal_ota_tail_0.tail.n14 0.0233288
R11250 bgr_djalal_0.bgr_djalal_ota_1_stage_0.bgr_djalal_ota_tail_0.tail.n19 bgr_djalal_0.bgr_djalal_ota_1_stage_0.bgr_djalal_ota_tail_0.tail.n18 0.0233288
R11251 bgr_djalal_0.bgr_djalal_ota_1_stage_0.bgr_djalal_ota_tail_0.tail.n21 bgr_djalal_0.bgr_djalal_ota_1_stage_0.bgr_djalal_ota_tail_0.tail.n20 0.0233288
R11252 bgr_djalal_0.bgr_djalal_ota_1_stage_0.bgr_djalal_ota_tail_0.tail.n6 bgr_djalal_0.bgr_djalal_ota_1_stage_0.bgr_djalal_ota_tail_0.tail.n5 0.0231719
R11253 bgr_djalal_0.bgr_djalal_ota_1_stage_0.bgr_djalal_ota_tail_0.tail.n10 bgr_djalal_0.bgr_djalal_ota_1_stage_0.bgr_djalal_ota_tail_0.tail.n9 0.0231719
R11254 bgr_djalal_0.bgr_djalal_ota_1_stage_0.bgr_djalal_ota_tail_0.tail.n16 bgr_djalal_0.bgr_djalal_ota_1_stage_0.bgr_djalal_ota_tail_0.tail.n15 0.0231719
R11255 bgr_djalal_0.bgr_djalal_ota_1_stage_0.bgr_djalal_ota_tail_0.tail.n20 bgr_djalal_0.bgr_djalal_ota_1_stage_0.bgr_djalal_ota_tail_0.tail.n19 0.0231719
R11256 bgr_djalal_0.bgr_djalal_ota_1_stage_0.bgr_djalal_ota_tail_0.tail.n24 bgr_djalal_0.bgr_djalal_ota_1_stage_0.bgr_djalal_ota_tail_0.tail.n23 0.0231719
R11257 bgr_djalal_0.bgr_djalal_ota_1_stage_0.bgr_djalal_ota_tail_0.tail.n9 bgr_djalal_0.bgr_djalal_ota_1_stage_0.bgr_djalal_ota_tail_0.tail.n8 0.0231719
R11258 bgr_djalal_0.bgr_djalal_ota_1_stage_0.bgr_djalal_ota_tail_0.tail.n13 bgr_djalal_0.bgr_djalal_ota_1_stage_0.bgr_djalal_ota_tail_0.tail.n12 0.0231719
R11259 bgr_djalal_0.bgr_djalal_ota_1_stage_0.bgr_djalal_ota_tail_0.tail.n17 bgr_djalal_0.bgr_djalal_ota_1_stage_0.bgr_djalal_ota_tail_0.tail.n16 0.0231719
R11260 bgr_djalal_0.bgr_djalal_ota_1_stage_0.bgr_djalal_ota_tail_0.tail.n23 bgr_djalal_0.bgr_djalal_ota_1_stage_0.bgr_djalal_ota_tail_0.tail.n22 0.0231719
R11261 bgr_djalal_0.bgr_djalal_ota_1_stage_0.bgr_djalal_ota_tail_0.tail bgr_djalal_0.bgr_djalal_ota_1_stage_0.bgr_djalal_ota_tail_0.tail.n2 0.0148089
R11262 bgr_djalal_0.bgr_djalal_ota_1_stage_0.bgr_djalal_ota_tail_0.tail.n28 bgr_djalal_0.bgr_djalal_ota_1_stage_0.bgr_djalal_ota_tail_0.tail.n27 0.0118359
R11263 bgr_djalal_0.bgr_djalal_ota_1_stage_0.bgr_djalal_ota_tail_0.tail.n26 bgr_djalal_0.bgr_djalal_ota_1_stage_0.bgr_djalal_ota_tail_0.tail.n24 0.0118359
R11264 bgr_djalal_0.bgr_djalal_ota_1_stage_0.bgr_djalal_ota_tail_0.tail.n29 bgr_djalal_0.bgr_djalal_ota_1_stage_0.bgr_djalal_ota_tail_0.tail.n28 0.00772857
R11265 bgr_djalal_0.bgr_djalal_ota_1_stage_0.bgr_djalal_ota_mirror_0.Iref.n0 bgr_djalal_0.bgr_djalal_ota_1_stage_0.bgr_djalal_ota_mirror_0.Iref.t0 18.7721
R11266 bgr_djalal_0.bgr_djalal_ota_1_stage_0.bgr_djalal_ota_mirror_0.Iref.n1 bgr_djalal_0.bgr_djalal_ota_1_stage_0.bgr_djalal_ota_mirror_0.Iref.t4 9.04456
R11267 bgr_djalal_0.bgr_djalal_ota_1_stage_0.bgr_djalal_ota_mirror_0.Iref.n2 bgr_djalal_0.bgr_djalal_ota_1_stage_0.bgr_djalal_ota_mirror_0.Iref.t3 5.68194
R11268 bgr_djalal_0.bgr_djalal_ota_1_stage_0.bgr_djalal_ota_mirror_0.Iref bgr_djalal_0.bgr_djalal_ota_1_stage_0.bgr_djalal_ota_mirror_0.Iref.n2 5.32004
R11269 bgr_djalal_0.bgr_djalal_ota_1_stage_0.bgr_djalal_ota_mirror_0.Iref bgr_djalal_0.bgr_djalal_ota_1_stage_0.bgr_djalal_ota_mirror_0.Iref.n0 4.30548
R11270 bgr_djalal_0.bgr_djalal_ota_1_stage_0.bgr_djalal_ota_mirror_0.Iref.n2 bgr_djalal_0.bgr_djalal_ota_1_stage_0.bgr_djalal_ota_mirror_0.Iref.n1 3.50919
R11271 bgr_djalal_0.bgr_djalal_ota_1_stage_0.bgr_djalal_ota_mirror_0.Iref.n0 bgr_djalal_0.bgr_djalal_ota_1_stage_0.bgr_djalal_ota_mirror_0.Iref.t1 0.165438
R11272 bgr_djalal_0.bgr_djalal_ota_1_stage_0.bgr_djalal_ota_mirror_0.Iref.n1 bgr_djalal_0.bgr_djalal_ota_1_stage_0.bgr_djalal_ota_mirror_0.Iref.t2 0.00820567
R11273 bgr_djalal_0.bgr_djalal_ota_1_stage_0.VP.n0 bgr_djalal_0.bgr_djalal_ota_1_stage_0.VP.t2 25.1555
R11274 bgr_djalal_0.bgr_djalal_ota_1_stage_0.VP.n1 bgr_djalal_0.bgr_djalal_ota_1_stage_0.VP.t4 24.1925
R11275 bgr_djalal_0.bgr_djalal_ota_1_stage_0.VP.n0 bgr_djalal_0.bgr_djalal_ota_1_stage_0.VP.t1 21.9924
R11276 bgr_djalal_0.bgr_djalal_ota_1_stage_0.VP.n2 bgr_djalal_0.bgr_djalal_ota_1_stage_0.VP 17.1011
R11277 bgr_djalal_0.bgr_djalal_ota_1_stage_0.VP.n3 bgr_djalal_0.bgr_djalal_ota_1_stage_0.VP.t3 15.2001
R11278 bgr_djalal_0.bgr_djalal_ota_1_stage_0.VP.n3 bgr_djalal_0.bgr_djalal_ota_1_stage_0.VP.t0 15.1874
R11279 bgr_djalal_0.bgr_djalal_ota_1_stage_0.VP.n4 bgr_djalal_0.bgr_djalal_ota_1_stage_0.VP.n2 11.5009
R11280 bgr_djalal_0.bgr_djalal_ota_1_stage_0.VP bgr_djalal_0.bgr_djalal_ota_1_stage_0.VP.n1 9.59793
R11281 bgr_djalal_0.bgr_djalal_ota_1_stage_0.VP.n2 bgr_djalal_0.bgr_djalal_ota_1_stage_0.VP 7.2681
R11282 bgr_djalal_0.bgr_djalal_ota_1_stage_0.VP bgr_djalal_0.bgr_djalal_ota_1_stage_0.VP.n0 6.9855
R11283 bgr_djalal_0.bgr_djalal_ota_1_stage_0.VP.n1 bgr_djalal_0.bgr_djalal_ota_1_stage_0.VP.t5 2.46208
R11284 bgr_djalal_0.bgr_djalal_ota_1_stage_0.VP.n4 bgr_djalal_0.bgr_djalal_ota_1_stage_0.VP.n3 2.2505
R11285 bgr_djalal_0.bgr_djalal_ota_1_stage_0.VP bgr_djalal_0.bgr_djalal_ota_1_stage_0.VP.n4 0.0191277
R11286 bgr_djalal_0.bgr_djalal_resistors_0.VP1 bgr_djalal_0.bgr_djalal_resistors_0.VP1.t0 43.9323
R11287 bgr_djalal_0.bgr_djalal_resistors_0.VP1 bgr_djalal_0.bgr_djalal_resistors_0.VP1.n2 7.31486
R11288 bgr_djalal_0.bgr_djalal_resistors_0.VP1.n1 bgr_djalal_0.bgr_djalal_resistors_0.VP1.n0 4.35925
R11289 bgr_djalal_0.bgr_djalal_resistors_0.VP1.n1 bgr_djalal_0.bgr_djalal_resistors_0.VP1.t3 2.55735
R11290 bgr_djalal_0.bgr_djalal_resistors_0.VP1.n0 bgr_djalal_0.bgr_djalal_resistors_0.VP1.t1 2.55088
R11291 bgr_djalal_0.bgr_djalal_resistors_0.VP1.n0 bgr_djalal_0.bgr_djalal_resistors_0.VP1.t2 2.14097
R11292 bgr_djalal_0.bgr_djalal_resistors_0.VP1.n2 bgr_djalal_0.bgr_djalal_resistors_0.VP1.n1 1.78927
R11293 bgr_djalal_0.bgr_djalal_resistors_0.VP1.n2 bgr_djalal_0.bgr_djalal_resistors_0.VP1.t4 0.349631
R11294 a_5838_14426.t0 a_5838_14426.t1 30.559
R11295 a_5574_11258.t0 a_5574_11258.t1 30.559
R11296 a_13630_7350.t0 a_13630_7350.t1 30.559
R11297 ldo_brahim_0.ldo_brahim_opamp_2_stage_0/ldo_brahim_mirror_0.i_ref.n2 ldo_brahim_0.ldo_brahim_opamp_2_stage_0/ldo_brahim_mirror_0.i_ref.t0 19.9186
R11298 ldo_brahim_0.ldo_brahim_opamp_2_stage_0/ldo_brahim_mirror_0.i_ref.n0 ldo_brahim_0.ldo_brahim_opamp_2_stage_0/ldo_brahim_mirror_0.i_ref.t4 12.477
R11299 ldo_brahim_0.ldo_brahim_opamp_2_stage_0/ldo_brahim_mirror_0.i_ref.n1 ldo_brahim_0.ldo_brahim_opamp_2_stage_0/ldo_brahim_mirror_0.i_ref.n0 11.8938
R11300 ldo_brahim_0.ldo_brahim_opamp_2_stage_0/ldo_brahim_mirror_0.i_ref ldo_brahim_0.ldo_brahim_opamp_2_stage_0/ldo_brahim_mirror_0.i_ref.n2 5.04961
R11301 ldo_brahim_0.ldo_brahim_opamp_2_stage_0/ldo_brahim_mirror_0.i_ref ldo_brahim_0.ldo_brahim_opamp_2_stage_0/ldo_brahim_mirror_0.i_ref.n1 4.51714
R11302 ldo_brahim_0.ldo_brahim_opamp_2_stage_0/ldo_brahim_mirror_0.i_ref.n0 ldo_brahim_0.ldo_brahim_opamp_2_stage_0/ldo_brahim_mirror_0.i_ref.t2 2.77235
R11303 ldo_brahim_0.ldo_brahim_opamp_2_stage_0/ldo_brahim_mirror_0.i_ref.n2 ldo_brahim_0.ldo_brahim_opamp_2_stage_0/ldo_brahim_mirror_0.i_ref.t1 0.858123
R11304 ldo_brahim_0.ldo_brahim_opamp_2_stage_0/ldo_brahim_mirror_0.i_ref.n3 ldo_brahim_0.ldo_brahim_opamp_2_stage_0/ldo_brahim_mirror_0.i_ref 0.292402
R11305 ldo_brahim_0.ldo_brahim_opamp_2_stage_0/ldo_brahim_mirror_0.i_ref.n1 ldo_brahim_0.ldo_brahim_opamp_2_stage_0/ldo_brahim_mirror_0.i_ref.t3 0.140297
R11306 ldo_brahim_0.ldo_brahim_opamp_2_stage_0/ldo_brahim_mirror_0.i_ref.n3 ldo_brahim_0.ldo_brahim_opamp_2_stage_0/ldo_brahim_mirror_0.i_ref 0.0115
R11307 ldo_brahim_0.ldo_brahim_opamp_2_stage_0/ldo_brahim_mirror_0.i_ref ldo_brahim_0.ldo_brahim_opamp_2_stage_0/ldo_brahim_mirror_0.i_ref.n3 0.0112317
R11308 a_4959_2048.t0 a_4959_2048.t1 30.559
R11309 a_5574_11016.t0 a_5574_11016.t1 30.559
R11310 a_5838_7848.t0 a_5838_7848.t1 30.559
R11311 a_15716_7350.t0 a_15716_7350.t1 30.3117
R11312 a_11060_8670.t0 a_11060_8670.t1 51.8631
R11313 a_3073_1784.t0 a_3073_1784.t1 30.559
R11314 bgr_djalal_0.bgr_djalal_start_up_0.bgr_djalal_start_up_mirror_0.Iref.n6 bgr_djalal_0.bgr_djalal_start_up_0.bgr_djalal_start_up_mirror_0.Iref.t5 8.97238
R11315 bgr_djalal_0.bgr_djalal_start_up_0.bgr_djalal_start_up_mirror_0.Iref.n2 bgr_djalal_0.bgr_djalal_start_up_0.bgr_djalal_start_up_mirror_0.Iref.t2 8.66627
R11316 bgr_djalal_0.bgr_djalal_start_up_0.bgr_djalal_start_up_mirror_0.Iref.n1 bgr_djalal_0.bgr_djalal_start_up_0.bgr_djalal_start_up_mirror_0.Iref.t0 8.27699
R11317 bgr_djalal_0.bgr_djalal_start_up_0.bgr_djalal_start_up_mirror_0.Iref.t0 bgr_djalal_0.bgr_djalal_start_up_0.bgr_djalal_start_up_mirror_0.Iref.n0 7.501
R11318 bgr_djalal_0.bgr_djalal_start_up_0.bgr_djalal_start_up_mirror_0.Iref.n3 bgr_djalal_0.bgr_djalal_start_up_0.bgr_djalal_start_up_mirror_0.Iref.n0 6.97678
R11319 bgr_djalal_0.bgr_djalal_start_up_0.bgr_djalal_start_up_mirror_0.Iref.n4 bgr_djalal_0.bgr_djalal_start_up_0.bgr_djalal_start_up_mirror_0.Iref.t4 6.09201
R11320 bgr_djalal_0.bgr_djalal_start_up_0.bgr_djalal_start_up_mirror_0.Iref.t2 bgr_djalal_0.bgr_djalal_start_up_0.bgr_djalal_start_up_mirror_0.Iref.n1 4.14206
R11321 bgr_djalal_0.bgr_djalal_start_up_0.bgr_djalal_start_up_mirror_0.Iref.n0 bgr_djalal_0.bgr_djalal_start_up_0.bgr_djalal_start_up_mirror_0.Iref.t1 3.61045
R11322 bgr_djalal_0.bgr_djalal_start_up_0.bgr_djalal_start_up_mirror_0.Iref.n4 bgr_djalal_0.bgr_djalal_start_up_0.bgr_djalal_start_up_mirror_0.Iref.t3 2.75664
R11323 bgr_djalal_0.bgr_djalal_start_up_0.bgr_djalal_start_up_mirror_0.Iref.n5 bgr_djalal_0.bgr_djalal_start_up_0.bgr_djalal_start_up_mirror_0.Iref.n4 2.42339
R11324 bgr_djalal_0.bgr_djalal_start_up_0.bgr_djalal_start_up_mirror_0.Iref.n3 bgr_djalal_0.bgr_djalal_start_up_0.bgr_djalal_start_up_mirror_0.Iref.n2 1.5005
R11325 bgr_djalal_0.bgr_djalal_start_up_0.bgr_djalal_start_up_mirror_0.Iref.n5 bgr_djalal_0.bgr_djalal_start_up_0.bgr_djalal_start_up_mirror_0.Iref.n3 1.35414
R11326 bgr_djalal_0.bgr_djalal_start_up_0.bgr_djalal_start_up_mirror_0.Iref.n6 bgr_djalal_0.bgr_djalal_start_up_0.bgr_djalal_start_up_mirror_0.Iref.n5 0.884287
R11327 bgr_djalal_0.bgr_djalal_start_up_0.bgr_djalal_start_up_mirror_0.Iref.n2 bgr_djalal_0.bgr_djalal_start_up_0.bgr_djalal_start_up_mirror_0.Iref.n1 0.321773
R11328 bgr_djalal_0.bgr_djalal_start_up_0.bgr_djalal_start_up_mirror_0.Iref.n7 bgr_djalal_0.bgr_djalal_start_up_0.bgr_djalal_start_up_mirror_0.Iref 0.104029
R11329 bgr_djalal_0.bgr_djalal_start_up_0.bgr_djalal_start_up_mirror_0.Iref.n7 bgr_djalal_0.bgr_djalal_start_up_0.bgr_djalal_start_up_mirror_0.Iref.n6 0.0388429
R11330 bgr_djalal_0.bgr_djalal_start_up_0.bgr_djalal_start_up_mirror_0.Iref bgr_djalal_0.bgr_djalal_start_up_0.bgr_djalal_start_up_mirror_0.Iref.n7 0.0111857
R11331 a_4782_14426.t0 a_4782_14426.t1 30.559
R11332 a_5046_11258.t0 a_5046_11258.t1 30.559
R11333 a_11302_8142.t0 a_11302_8142.t1 30.559
R11334 a_13388_8406.t0 a_13388_8406.t1 30.2588
R11335 a_6646_7878.t0 a_6646_7878.t1 30.559
R11336 a_8732_7614.t0 a_8732_7614.t1 30.559
R11337 a_4782_7848.t0 a_4782_7848.t1 30.559
R11338 a_8974_7878.t0 a_8974_7878.t1 30.559
R11339 a_11060_7614.t0 a_11060_7614.t1 30.559
R11340 bgr_djalal_0.bgr_djalal_start_up_0.bgr_djalal_start_up_enable_0.Icpy.n0 bgr_djalal_0.bgr_djalal_start_up_0.bgr_djalal_start_up_enable_0.Icpy.t1 14.9732
R11341 bgr_djalal_0.bgr_djalal_start_up_0.bgr_djalal_start_up_enable_0.Icpy.n1 bgr_djalal_0.bgr_djalal_start_up_0.bgr_djalal_start_up_enable_0.Icpy.t3 7.90277
R11342 bgr_djalal_0.bgr_djalal_start_up_0.bgr_djalal_start_up_enable_0.Icpy.n1 bgr_djalal_0.bgr_djalal_start_up_0.bgr_djalal_start_up_enable_0.Icpy.t2 4.59117
R11343 bgr_djalal_0.bgr_djalal_start_up_0.bgr_djalal_start_up_enable_0.Icpy.n0 bgr_djalal_0.bgr_djalal_start_up_0.bgr_djalal_start_up_enable_0.Icpy.t0 4.44726
R11344 bgr_djalal_0.bgr_djalal_start_up_0.bgr_djalal_start_up_enable_0.Icpy bgr_djalal_0.bgr_djalal_start_up_0.bgr_djalal_start_up_enable_0.Icpy.n0 2.45876
R11345 bgr_djalal_0.bgr_djalal_start_up_0.bgr_djalal_start_up_enable_0.Icpy bgr_djalal_0.bgr_djalal_start_up_0.bgr_djalal_start_up_enable_0.Icpy.n1 0.3371
R11346 a_8974_7350.t0 a_8974_7350.t1 30.559
R11347 a_5310_14426.t0 a_5310_14426.t1 30.559
R11348 VFB VFB.n1 45.4659
R11349 VFB.n1 VFB.t0 15.4743
R11350 VFB.n1 VFB.t1 15.0851
R11351 VFB.n0 VFB.t2 8.94654
R11352 VFB.n0 VFB.t3 7.83753
R11353 VFB VFB.n0 2.49897
R11354 a_15716_7086.t0 a_15716_7086.t1 30.628
R11355 a_11060_7086.t0 a_11060_7086.t1 51.8631
R11356 a_4782_11016.t0 a_4782_11016.t1 30.2588
R11357 a_11302_7614.t0 a_11302_7614.t1 30.559
R11358 a_13388_7878.t0 a_13388_7878.t1 30.559
R11359 a_8732_7350.t0 a_8732_7350.t1 30.3831
R11360 a_15716_8670.t0 a_15716_8670.t1 30.385
C190 VDD VSS 18.89274f
C191 VFB VSS 9.50038f
C192 VR VSS 14.46885f
C193 Vbg VSS 14.74104f
C194 IOVDD VSS 63.97938f
C195 a_3159_1520# VSS 1.134f
C196 a_5183_1843# VSS 0.40823f
C197 a_3159_1784# VSS 0.90427f
C198 a_3159_2048# VSS 0.89806f
C199 a_3159_2312# VSS 0.92277f
C200 a_2835_1843# VSS 0.47002f
C201 a_3159_2576# VSS 1.10992f
C202 ldo_brahim_0.ldo_brahim_opamp_2_stage_0/ldo_brahim_tail_0.tail VSS 1.26281f $ **FLOATING
C203 ldo_brahim_0.ldo_brahim_opamp_2_stage_0/ldo_brahim_mirror_0.i_ref VSS 15.99842f $ **FLOATING
C204 a_7319_3508# VSS 0.03257f $ **FLOATING
C205 ldo_brahim_0.ldo_brahim_pass_element2_0.VG2 VSS 0.14128p $ **FLOATING
C206 ldo_brahim_0.ldo_brahim_opamp_2_stage_0/ldo_brahim_cs_0.VG VSS 40.02398f $ **FLOATING
C207 a_16044_7086# VSS 1.60669f
C208 a_13716_7086# VSS 1.2195f
C209 a_11388_7086# VSS 1.66798f
C210 a_9060_7086# VSS 1.23484f
C211 a_6732_7086# VSS 1.69476f
C212 a_16044_7350# VSS 1.08032f
C213 a_13716_7350# VSS 1.01411f
C214 a_11388_7350# VSS 1.05882f
C215 a_9060_7350# VSS 1.00247f
C216 a_6732_7350# VSS 1.0494f
C217 a_16044_7614# VSS 1.01297f
C218 a_13716_7614# VSS 1.00271f
C219 a_11388_7614# VSS 1.01058f
C220 a_9060_7614# VSS 0.99266f
C221 a_6732_7614# VSS 1.00293f
C222 a_16044_7878# VSS 1.00539f
C223 a_13716_7878# VSS 0.9993f
C224 a_11388_7878# VSS 1.00322f
C225 a_9060_7878# VSS 0.99073f
C226 a_6732_7878# VSS 0.99685f
C227 a_16044_8142# VSS 1.00288f
C228 a_13716_8142# VSS 0.99266f
C229 a_11388_8142# VSS 1.00266f
C230 a_9060_8142# VSS 0.99266f
C231 a_6732_8142# VSS 1.00293f
C232 a_16044_8406# VSS 1.04967f
C233 a_13716_8406# VSS 1.00247f
C234 a_11388_8406# VSS 1.0494f
C235 a_9060_8406# VSS 1.00247f
C236 a_6732_8406# VSS 1.04995f
C237 a_16044_8670# VSS 1.7236f
C238 a_13716_8670# VSS 1.2547f
C239 a_11388_8670# VSS 1.64537f
C240 a_9060_8670# VSS 1.2524f
C241 a_6732_8670# VSS 1.73377f
C242 a_7710_8970# VSS 0.16222f $ **FLOATING
C243 bgr_djalal_0.bgr_djalal_resistors_0.VP1 VSS 21.41204f $ **FLOATING
C244 bgr_djalal_0.bgr_djalal_ota_1_stage_0.bgr_djalal_ota_mirror_0.Iref VSS 11.51906f $ **FLOATING
C245 a_6102_7934# VSS 2.03015f
C246 a_5838_7934# VSS 1.54892f
C247 a_5574_7934# VSS 1.53326f
C248 a_5310_7934# VSS 1.53326f
C249 a_5046_7934# VSS 1.54892f
C250 a_4782_7934# VSS 1.9448f
C251 a_6102_11344# VSS 1.96928f
C252 a_5838_11344# VSS 1.54892f
C253 a_5574_11344# VSS 1.53326f
C254 a_5310_11344# VSS 1.53326f
C255 a_5046_11344# VSS 1.54892f
C256 a_4782_11344# VSS 1.97367f
C257 bgr_djalal_0.bgr_djalal_start_up_0.bgr_djalal_start_up_enable_0.Icpy VSS 3.1614f $ **FLOATING
C258 bgr_djalal_0.bgr_djalal_start_up_0.bgr_djalal_start_up_mirror_0.Iref VSS 4.01943f $ **FLOATING
C259 bgr_djalal_0.bgr_djalal_ota_1_stage_0.VP VSS 6.25088f $ **FLOATING
C260 bgr_djalal_0.bgr_djalal_ota_1_stage_0.VN VSS 13.76772f $ **FLOATING
C261 bgr_djalal_0.bgr_djalal_ota_1_stage_0.Vout1 VSS 15.92231f $ **FLOATING
C262 bgr_djalal_0.bgr_djalal_ota_1_stage_0.bgr_djalal_ota_tail_0.tail VSS 1.79862f $ **FLOATING
C263 beta_multiplier_0.beta_multiplier_mirror_0.VN VSS 13.10382f $ **FLOATING
C264 ldo_brahim_0.I_Bias VSS 54.4177f $ **FLOATING
C265 beta_multiplier_0.beta_multiplier_startup_0.beta_multiplier_startup_enable_0.VS1 VSS 35.10265f $ **FLOATING
C266 beta_multiplier_0.beta_multiplier_startup_0.beta_multiplier_startup_mirror_0.VS2 VSS 6.93785f $ **FLOATING
C267 a_11060_7086.t1 VSS 1.04998f $ **FLOATING
C268 a_11060_7086.t0 VSS 1.05002f $ **FLOATING
C269 VFB.t2 VSS 2.79163f $ **FLOATING
C270 VFB.t3 VSS 2.76646f $ **FLOATING
C271 VFB.n0 VSS 0.43178f $ **FLOATING
C272 VFB.t0 VSS 0.05672f $ **FLOATING
C273 VFB.t1 VSS 0.05523f $ **FLOATING
C274 VFB.n1 VSS 1.35849f $ **FLOATING
C275 bgr_djalal_0.bgr_djalal_start_up_0.bgr_djalal_start_up_mirror_0.Iref.t1 VSS 0.03496f $ **FLOATING
C276 bgr_djalal_0.bgr_djalal_start_up_0.bgr_djalal_start_up_mirror_0.Iref.n0 VSS 0.032f $ **FLOATING
C277 bgr_djalal_0.bgr_djalal_start_up_0.bgr_djalal_start_up_mirror_0.Iref.t0 VSS 0.51428f $ **FLOATING
C278 bgr_djalal_0.bgr_djalal_start_up_0.bgr_djalal_start_up_mirror_0.Iref.n1 VSS 0.01522f $ **FLOATING
C279 bgr_djalal_0.bgr_djalal_start_up_0.bgr_djalal_start_up_mirror_0.Iref.t2 VSS 0.03174f $ **FLOATING
C280 bgr_djalal_0.bgr_djalal_start_up_0.bgr_djalal_start_up_mirror_0.Iref.n2 VSS 0.01531f $ **FLOATING
C281 bgr_djalal_0.bgr_djalal_start_up_0.bgr_djalal_start_up_mirror_0.Iref.n3 VSS 0.05994f $ **FLOATING
C282 bgr_djalal_0.bgr_djalal_start_up_0.bgr_djalal_start_up_mirror_0.Iref.t4 VSS 0.05199f $ **FLOATING
C283 bgr_djalal_0.bgr_djalal_start_up_0.bgr_djalal_start_up_mirror_0.Iref.t3 VSS 0.03165f $ **FLOATING
C284 bgr_djalal_0.bgr_djalal_start_up_0.bgr_djalal_start_up_mirror_0.Iref.n4 VSS 0.0558f $ **FLOATING
C285 bgr_djalal_0.bgr_djalal_start_up_0.bgr_djalal_start_up_mirror_0.Iref.n5 VSS 0.0251f $ **FLOATING
C286 bgr_djalal_0.bgr_djalal_start_up_0.bgr_djalal_start_up_mirror_0.Iref.t5 VSS 2.57306f $ **FLOATING
C287 bgr_djalal_0.bgr_djalal_start_up_0.bgr_djalal_start_up_mirror_0.Iref.n6 VSS 0.05322f $ **FLOATING
C288 ldo_brahim_0.ldo_brahim_opamp_2_stage_0/ldo_brahim_mirror_0.i_ref.t3 VSS 0.21033f $ **FLOATING
C289 ldo_brahim_0.ldo_brahim_opamp_2_stage_0/ldo_brahim_mirror_0.i_ref.t4 VSS 0.31721f $ **FLOATING
C290 ldo_brahim_0.ldo_brahim_opamp_2_stage_0/ldo_brahim_mirror_0.i_ref.t2 VSS 5.38856f $ **FLOATING
C291 ldo_brahim_0.ldo_brahim_opamp_2_stage_0/ldo_brahim_mirror_0.i_ref.n0 VSS 0.16528f $ **FLOATING
C292 ldo_brahim_0.ldo_brahim_opamp_2_stage_0/ldo_brahim_mirror_0.i_ref.n1 VSS 0.09935f $ **FLOATING
C293 ldo_brahim_0.ldo_brahim_opamp_2_stage_0/ldo_brahim_mirror_0.i_ref.t1 VSS 0.10552f $ **FLOATING
C294 ldo_brahim_0.ldo_brahim_opamp_2_stage_0/ldo_brahim_mirror_0.i_ref.t0 VSS 0.22287f $ **FLOATING
C295 ldo_brahim_0.ldo_brahim_opamp_2_stage_0/ldo_brahim_mirror_0.i_ref.n2 VSS 0.20056f $ **FLOATING
C296 bgr_djalal_0.bgr_djalal_resistors_0.VP1.t4 VSS 0.05134f $ **FLOATING
C297 bgr_djalal_0.bgr_djalal_resistors_0.VP1.t2 VSS 0.06639f $ **FLOATING
C298 bgr_djalal_0.bgr_djalal_resistors_0.VP1.t1 VSS 0.62336f $ **FLOATING
C299 bgr_djalal_0.bgr_djalal_resistors_0.VP1.n0 VSS 0.02773f $ **FLOATING
C300 bgr_djalal_0.bgr_djalal_resistors_0.VP1.t3 VSS 0.62337f $ **FLOATING
C301 bgr_djalal_0.bgr_djalal_resistors_0.VP1.n1 VSS 0.0248f $ **FLOATING
C302 bgr_djalal_0.bgr_djalal_resistors_0.VP1.n2 VSS 0.03613f $ **FLOATING
C303 bgr_djalal_0.bgr_djalal_resistors_0.VP1.t0 VSS 0.09184f $ **FLOATING
C304 bgr_djalal_0.bgr_djalal_ota_1_stage_0.VP.t1 VSS 0.03863f $ **FLOATING
C305 bgr_djalal_0.bgr_djalal_ota_1_stage_0.VP.t2 VSS 0.06544f $ **FLOATING
C306 bgr_djalal_0.bgr_djalal_ota_1_stage_0.VP.n0 VSS 0.69722f $ **FLOATING
C307 bgr_djalal_0.bgr_djalal_ota_1_stage_0.VP.t5 VSS 9.54614f $ **FLOATING
C308 bgr_djalal_0.bgr_djalal_ota_1_stage_0.VP.t4 VSS 9.66409f $ **FLOATING
C309 bgr_djalal_0.bgr_djalal_ota_1_stage_0.VP.n1 VSS 0.55419f $ **FLOATING
C310 bgr_djalal_0.bgr_djalal_ota_1_stage_0.VP.n2 VSS 1.37898f $ **FLOATING
C311 bgr_djalal_0.bgr_djalal_ota_1_stage_0.VP.t0 VSS 0.0404f $ **FLOATING
C312 bgr_djalal_0.bgr_djalal_ota_1_stage_0.VP.t3 VSS 0.04042f $ **FLOATING
C313 bgr_djalal_0.bgr_djalal_ota_1_stage_0.VP.n3 VSS 0.13248f $ **FLOATING
C314 bgr_djalal_0.bgr_djalal_ota_1_stage_0.VP.n4 VSS 0.87289f $ **FLOATING
C315 bgr_djalal_0.bgr_djalal_ota_1_stage_0.bgr_djalal_ota_mirror_0.Iref.t1 VSS 0.24471f $ **FLOATING
C316 bgr_djalal_0.bgr_djalal_ota_1_stage_0.bgr_djalal_ota_mirror_0.Iref.t0 VSS 0.52956f $ **FLOATING
C317 bgr_djalal_0.bgr_djalal_ota_1_stage_0.bgr_djalal_ota_mirror_0.Iref.n0 VSS 0.29591f $ **FLOATING
C318 bgr_djalal_0.bgr_djalal_ota_1_stage_0.bgr_djalal_ota_mirror_0.Iref.t2 VSS 3.89723f $ **FLOATING
C319 bgr_djalal_0.bgr_djalal_ota_1_stage_0.bgr_djalal_ota_mirror_0.Iref.t4 VSS 0.04255f $ **FLOATING
C320 bgr_djalal_0.bgr_djalal_ota_1_stage_0.bgr_djalal_ota_mirror_0.Iref.n1 VSS 0.23778f $ **FLOATING
C321 bgr_djalal_0.bgr_djalal_ota_1_stage_0.bgr_djalal_ota_mirror_0.Iref.t3 VSS 0.02443f $ **FLOATING
C322 bgr_djalal_0.bgr_djalal_ota_1_stage_0.bgr_djalal_ota_mirror_0.Iref.n2 VSS 0.05457f $ **FLOATING
C323 bgr_djalal_0.bgr_djalal_ota_1_stage_0.bgr_djalal_ota_tail_0.tail.t1 VSS 0.45872f $ **FLOATING
C324 bgr_djalal_0.bgr_djalal_ota_1_stage_0.bgr_djalal_ota_tail_0.tail.t3 VSS 0.50694f $ **FLOATING
C325 bgr_djalal_0.bgr_djalal_ota_1_stage_0.bgr_djalal_ota_tail_0.tail.n0 VSS 0.11913f $ **FLOATING
C326 bgr_djalal_0.bgr_djalal_ota_1_stage_0.bgr_djalal_ota_tail_0.tail.t2 VSS 0.49515f $ **FLOATING
C327 bgr_djalal_0.bgr_djalal_ota_1_stage_0.bgr_djalal_ota_tail_0.tail.n1 VSS 0.07613f $ **FLOATING
C328 bgr_djalal_0.bgr_djalal_ota_1_stage_0.bgr_djalal_ota_tail_0.tail.n2 VSS 0.03095f $ **FLOATING
C329 bgr_djalal_0.bgr_djalal_ota_1_stage_0.bgr_djalal_ota_tail_0.tail.n3 VSS 0.15437f $ **FLOATING
C330 bgr_djalal_0.bgr_djalal_ota_1_stage_0.bgr_djalal_ota_tail_0.tail.t6 VSS 0.31521f $ **FLOATING
C331 bgr_djalal_0.bgr_djalal_ota_1_stage_0.bgr_djalal_ota_tail_0.tail.n4 VSS 0.05584f $ **FLOATING
C332 bgr_djalal_0.bgr_djalal_ota_1_stage_0.bgr_djalal_ota_tail_0.tail.n5 VSS 0.05622f $ **FLOATING
C333 bgr_djalal_0.bgr_djalal_ota_1_stage_0.bgr_djalal_ota_tail_0.tail.n6 VSS 0.05622f $ **FLOATING
C334 bgr_djalal_0.bgr_djalal_ota_1_stage_0.bgr_djalal_ota_tail_0.tail.n7 VSS 0.05584f $ **FLOATING
C335 bgr_djalal_0.bgr_djalal_ota_1_stage_0.bgr_djalal_ota_tail_0.tail.n8 VSS 0.05622f $ **FLOATING
C336 bgr_djalal_0.bgr_djalal_ota_1_stage_0.bgr_djalal_ota_tail_0.tail.n9 VSS 0.05582f $ **FLOATING
C337 bgr_djalal_0.bgr_djalal_ota_1_stage_0.bgr_djalal_ota_tail_0.tail.n10 VSS 0.05622f $ **FLOATING
C338 bgr_djalal_0.bgr_djalal_ota_1_stage_0.bgr_djalal_ota_tail_0.tail.n11 VSS 0.05584f $ **FLOATING
C339 bgr_djalal_0.bgr_djalal_ota_1_stage_0.bgr_djalal_ota_tail_0.tail.n12 VSS 0.05622f $ **FLOATING
C340 bgr_djalal_0.bgr_djalal_ota_1_stage_0.bgr_djalal_ota_tail_0.tail.n13 VSS 0.05622f $ **FLOATING
C341 bgr_djalal_0.bgr_djalal_ota_1_stage_0.bgr_djalal_ota_tail_0.tail.n14 VSS 0.05584f $ **FLOATING
C342 bgr_djalal_0.bgr_djalal_ota_1_stage_0.bgr_djalal_ota_tail_0.tail.n15 VSS 0.05622f $ **FLOATING
C343 bgr_djalal_0.bgr_djalal_ota_1_stage_0.bgr_djalal_ota_tail_0.tail.n16 VSS 0.05582f $ **FLOATING
C344 bgr_djalal_0.bgr_djalal_ota_1_stage_0.bgr_djalal_ota_tail_0.tail.n17 VSS 0.05622f $ **FLOATING
C345 bgr_djalal_0.bgr_djalal_ota_1_stage_0.bgr_djalal_ota_tail_0.tail.n18 VSS 0.05584f $ **FLOATING
C346 bgr_djalal_0.bgr_djalal_ota_1_stage_0.bgr_djalal_ota_tail_0.tail.n19 VSS 0.05622f $ **FLOATING
C347 bgr_djalal_0.bgr_djalal_ota_1_stage_0.bgr_djalal_ota_tail_0.tail.n20 VSS 0.05622f $ **FLOATING
C348 bgr_djalal_0.bgr_djalal_ota_1_stage_0.bgr_djalal_ota_tail_0.tail.n21 VSS 0.05584f $ **FLOATING
C349 bgr_djalal_0.bgr_djalal_ota_1_stage_0.bgr_djalal_ota_tail_0.tail.n22 VSS 0.05622f $ **FLOATING
C350 bgr_djalal_0.bgr_djalal_ota_1_stage_0.bgr_djalal_ota_tail_0.tail.n23 VSS 0.05582f $ **FLOATING
C351 bgr_djalal_0.bgr_djalal_ota_1_stage_0.bgr_djalal_ota_tail_0.tail.n24 VSS 0.02791f $ **FLOATING
C352 bgr_djalal_0.bgr_djalal_ota_1_stage_0.bgr_djalal_ota_tail_0.tail.t5 VSS 0.44326f $ **FLOATING
C353 bgr_djalal_0.bgr_djalal_ota_1_stage_0.bgr_djalal_ota_tail_0.tail.t4 VSS 0.44369f $ **FLOATING
C354 bgr_djalal_0.bgr_djalal_ota_1_stage_0.bgr_djalal_ota_tail_0.tail.n25 VSS 1.12902f $ **FLOATING
C355 bgr_djalal_0.bgr_djalal_ota_1_stage_0.bgr_djalal_ota_tail_0.tail.n26 VSS 0.48365f $ **FLOATING
C356 bgr_djalal_0.bgr_djalal_ota_1_stage_0.bgr_djalal_ota_tail_0.tail.t0 VSS 0.3152f $ **FLOATING
C357 bgr_djalal_0.bgr_djalal_ota_1_stage_0.bgr_djalal_ota_tail_0.tail.n27 VSS 0.02831f $ **FLOATING
C358 bgr_djalal_0.bgr_djalal_ota_1_stage_0.bgr_djalal_ota_tail_0.tail.n28 VSS 0.03722f $ **FLOATING
C359 bgr_djalal_0.bgr_djalal_ota_1_stage_0.bgr_djalal_ota_tail_0.tail.n29 VSS 0.15615f $ **FLOATING
C360 bgr_djalal_0.bgr_djalal_ota_1_stage_0.VN.t1 VSS 0.05464f $ **FLOATING
C361 bgr_djalal_0.bgr_djalal_ota_1_stage_0.VN.t0 VSS 0.09093f $ **FLOATING
C362 bgr_djalal_0.bgr_djalal_ota_1_stage_0.VN.n0 VSS 0.47757f $ **FLOATING
C363 bgr_djalal_0.bgr_djalal_ota_1_stage_0.VN.t3 VSS 0.37663f $ **FLOATING
C364 bgr_djalal_0.bgr_djalal_ota_1_stage_0.VN.t2 VSS 4.61636f $ **FLOATING
C365 bgr_djalal_0.bgr_djalal_ota_1_stage_0.VN.n1 VSS 0.32317f $ **FLOATING
C366 bgr_djalal_0.bgr_djalal_ota_1_stage_0.VN.n2 VSS 0.38187f $ **FLOATING
C367 bgr_djalal_0.bgr_djalal_ota_1_stage_0.VN.t5 VSS 1.29694f $ **FLOATING
C368 bgr_djalal_0.bgr_djalal_ota_1_stage_0.VN.n3 VSS 0.25616f $ **FLOATING
C369 bgr_djalal_0.bgr_djalal_ota_1_stage_0.VN.t4 VSS 7.64603f $ **FLOATING
C370 bgr_djalal_0.bgr_djalal_ota_1_stage_0.VN.t6 VSS 7.54919f $ **FLOATING
C371 bgr_djalal_0.bgr_djalal_ota_1_stage_0.VN.n4 VSS 0.54594f $ **FLOATING
C372 bgr_djalal_0.bgr_djalal_ota_1_stage_0.VN.n5 VSS 0.73144f $ **FLOATING
C373 a_5183_1757.n0 VSS 1.17221f $ **FLOATING
C374 a_5183_1757.t0 VSS 35.0442f $ **FLOATING
C375 a_5183_1757.t1 VSS 3.34479f $ **FLOATING
C376 a_5183_1757.n1 VSS 0.04723f $ **FLOATING
C377 a_5183_1757.n2 VSS 0.04723f $ **FLOATING
C378 a_5183_1757.t2 VSS 0.02142f $ **FLOATING
C379 a_5183_1757.n3 VSS 0.04723f $ **FLOATING
C380 a_5183_1757.n4 VSS 0.04723f $ **FLOATING
C381 a_5183_1757.n5 VSS 0.04723f $ **FLOATING
C382 a_5183_1757.n6 VSS 1.17221f $ **FLOATING
C383 a_5183_1757.n7 VSS 0.04723f $ **FLOATING
C384 a_5183_1757.n8 VSS 0.04723f $ **FLOATING
C385 a_5183_1757.n9 VSS 0.04723f $ **FLOATING
C386 a_5183_1757.n10 VSS 0.04723f $ **FLOATING
C387 a_5183_1757.n11 VSS 0.04723f $ **FLOATING
C388 a_5183_1757.n12 VSS 1.17221f $ **FLOATING
C389 a_5183_1757.n13 VSS 0.04723f $ **FLOATING
C390 a_5183_1757.n14 VSS 0.04723f $ **FLOATING
C391 a_5183_1757.n15 VSS 0.04723f $ **FLOATING
C392 a_5183_1757.n16 VSS 0.04723f $ **FLOATING
C393 a_5183_1757.n17 VSS 0.04723f $ **FLOATING
C394 a_5183_1757.n18 VSS 1.17221f $ **FLOATING
C395 a_5183_1757.n19 VSS 0.04723f $ **FLOATING
C396 a_5183_1757.n20 VSS 0.04723f $ **FLOATING
C397 a_5183_1757.n21 VSS 0.03814f $ **FLOATING
C398 a_5183_1757.n22 VSS 6.22126f $ **FLOATING
C399 a_5183_1757.n23 VSS 1.17221f $ **FLOATING
C400 a_5183_1757.n24 VSS 0.04723f $ **FLOATING
C401 a_5183_1757.n25 VSS 0.04723f $ **FLOATING
C402 a_5183_1757.n26 VSS 0.04017f $ **FLOATING
C403 a_5183_1757.n27 VSS 0.12982f $ **FLOATING
C404 a_5183_1757.n28 VSS 0.04723f $ **FLOATING
C405 a_5183_1757.n29 VSS 0.04723f $ **FLOATING
C406 a_5183_1757.n30 VSS 0.04723f $ **FLOATING
C407 a_5183_1757.n31 VSS 1.17221f $ **FLOATING
C408 a_5183_1757.n32 VSS 1.17221f $ **FLOATING
C409 a_5183_1757.n33 VSS 1.17221f $ **FLOATING
C410 a_5183_1757.n34 VSS 0.04723f $ **FLOATING
C411 a_5183_1757.n35 VSS 0.04723f $ **FLOATING
C412 a_5183_1757.n36 VSS 0.04723f $ **FLOATING
C413 a_5183_1757.n37 VSS 0.04723f $ **FLOATING
C414 a_5183_1757.n38 VSS 0.04723f $ **FLOATING
C415 a_5183_1757.n39 VSS 0.04723f $ **FLOATING
C416 a_5183_1757.n40 VSS 0.04723f $ **FLOATING
C417 a_5183_1757.n41 VSS 1.17221f $ **FLOATING
C418 a_5183_1757.n42 VSS 1.17221f $ **FLOATING
C419 a_5183_1757.n43 VSS 1.17221f $ **FLOATING
C420 a_5183_1757.n44 VSS 0.04723f $ **FLOATING
C421 a_5183_1757.n45 VSS 0.04723f $ **FLOATING
C422 a_5183_1757.n46 VSS 0.04723f $ **FLOATING
C423 a_5183_1757.n47 VSS 0.04723f $ **FLOATING
C424 a_5183_1757.n48 VSS 0.04723f $ **FLOATING
C425 a_5183_1757.n49 VSS 0.04723f $ **FLOATING
C426 a_5183_1757.n50 VSS 0.04723f $ **FLOATING
C427 a_5183_1757.n51 VSS 0.78147f $ **FLOATING
C428 a_5183_1757.n52 VSS 0.5861f $ **FLOATING
C429 a_5183_1757.n53 VSS 0.97684f $ **FLOATING
C430 a_5183_1757.n54 VSS 1.17221f $ **FLOATING
C431 a_5183_1757.n55 VSS 0.04723f $ **FLOATING
C432 a_5183_1757.n56 VSS 0.04723f $ **FLOATING
C433 a_5183_1757.n57 VSS 0.04723f $ **FLOATING
C434 a_5183_1757.n58 VSS 0.02706f $ **FLOATING
C435 a_5183_1757.n59 VSS 0.11174f $ **FLOATING
C436 a_5183_1757.n60 VSS 0.03825f $ **FLOATING
C437 a_5183_1757.n61 VSS 0.03788f $ **FLOATING
C438 a_5183_1757.n62 VSS 8.29224f $ **FLOATING
C439 beta_multiplier_0.beta_multiplier_mirror_0.VN.t1 VSS 0.207f $ **FLOATING
C440 beta_multiplier_0.beta_multiplier_mirror_0.VN.n0 VSS 0.16156f $ **FLOATING
C441 beta_multiplier_0.beta_multiplier_mirror_0.VN.t0 VSS 0.18047f $ **FLOATING
C442 beta_multiplier_0.beta_multiplier_mirror_0.VN.n1 VSS 0.17685f $ **FLOATING
C443 beta_multiplier_0.beta_multiplier_mirror_0.VN.t4 VSS 1.07331f $ **FLOATING
C444 beta_multiplier_0.beta_multiplier_mirror_0.VN.t2 VSS 0.53031f $ **FLOATING
C445 beta_multiplier_0.beta_multiplier_mirror_0.VN.t5 VSS 1.08268f $ **FLOATING
C446 beta_multiplier_0.beta_multiplier_mirror_0.VN.n2 VSS 0.08526f $ **FLOATING
C447 beta_multiplier_0.beta_multiplier_mirror_0.VN.n3 VSS 0.02882f $ **FLOATING
C448 beta_multiplier_0.beta_multiplier_mirror_0.VN.t6 VSS 1.07331f $ **FLOATING
C449 beta_multiplier_0.beta_multiplier_mirror_0.VN.t3 VSS 1.08958f $ **FLOATING
C450 beta_multiplier_0.beta_multiplier_mirror_0.VN.n4 VSS 0.23875f $ **FLOATING
C451 beta_multiplier_0.beta_multiplier_mirror_0.VN.n5 VSS 0.51709f $ **FLOATING
C452 beta_multiplier_0.beta_multiplier_startup_0.beta_multiplier_startup_mirror_0.VS2.t0 VSS 0.39066f $ **FLOATING
C453 beta_multiplier_0.beta_multiplier_startup_0.beta_multiplier_startup_mirror_0.VS2.t1 VSS 0.04827f $ **FLOATING
C454 beta_multiplier_0.beta_multiplier_startup_0.beta_multiplier_startup_mirror_0.VS2.t3 VSS 0.12219f $ **FLOATING
C455 beta_multiplier_0.beta_multiplier_startup_0.beta_multiplier_startup_mirror_0.VS2.n1 VSS 0.02532f $ **FLOATING
C456 beta_multiplier_0.beta_multiplier_startup_0.beta_multiplier_startup_mirror_0.VS2.n2 VSS 0.02018f $ **FLOATING
C457 beta_multiplier_0.beta_multiplier_startup_0.beta_multiplier_startup_mirror_0.VS2.t2 VSS 0.03923f $ **FLOATING
C458 beta_multiplier_0.beta_multiplier_startup_0.beta_multiplier_startup_mirror_0.VS2.t4 VSS 3.10197f $ **FLOATING
C459 beta_multiplier_0.beta_multiplier_startup_0.beta_multiplier_startup_mirror_0.VS2.n5 VSS 0.03176f $ **FLOATING
C460 ldo_brahim_0.ldo_brahim_opamp_2_stage_0/ldo_brahim_cs_0.VG.t4 VSS 13.3338f $ **FLOATING
C461 ldo_brahim_0.ldo_brahim_opamp_2_stage_0/ldo_brahim_cs_0.VG.t6 VSS 62.1345f $ **FLOATING
C462 ldo_brahim_0.ldo_brahim_opamp_2_stage_0/ldo_brahim_cs_0.VG.t5 VSS 2.15813f $ **FLOATING
C463 ldo_brahim_0.ldo_brahim_opamp_2_stage_0/ldo_brahim_cs_0.VG.t7 VSS 1.04888f $ **FLOATING
C464 ldo_brahim_0.ldo_brahim_opamp_2_stage_0/ldo_brahim_cs_0.VG.t8 VSS 1.07497f $ **FLOATING
C465 ldo_brahim_0.ldo_brahim_opamp_2_stage_0/ldo_brahim_cs_0.VG.n2 VSS 0.02438f $ **FLOATING
C466 ldo_brahim_0.ldo_brahim_opamp_2_stage_0/ldo_brahim_cs_0.VG.n3 VSS 0.0354f $ **FLOATING
C467 ldo_brahim_0.ldo_brahim_opamp_2_stage_0/ldo_brahim_cs_0.VG.n4 VSS 0.12373f $ **FLOATING
C468 ldo_brahim_0.ldo_brahim_opamp_2_stage_0/ldo_brahim_cs_0.VG.t0 VSS 0.04408f $ **FLOATING
C469 ldo_brahim_0.ldo_brahim_opamp_2_stage_0/ldo_brahim_cs_0.VG.t1 VSS 0.09632f $ **FLOATING
C470 ldo_brahim_0.ldo_brahim_opamp_2_stage_0/ldo_brahim_cs_0.VG.n5 VSS 0.06411f $ **FLOATING
C471 ldo_brahim_0.ldo_brahim_opamp_2_stage_0/ldo_brahim_cs_0.VG.n6 VSS 0.01879f $ **FLOATING
C472 ldo_brahim_0.ldo_brahim_opamp_2_stage_0/ldo_brahim_cs_0.VG.t3 VSS 0.14621f $ **FLOATING
C473 ldo_brahim_0.ldo_brahim_opamp_2_stage_0/ldo_brahim_cs_0.VG.t2 VSS 0.08798f $ **FLOATING
C474 ldo_brahim_0.ldo_brahim_opamp_2_stage_0/ldo_brahim_cs_0.VG.n7 VSS 0.06344f $ **FLOATING
C475 Vbg.t3 VSS 0.02143f $ **FLOATING
C476 Vbg.t2 VSS 0.01114f $ **FLOATING
C477 Vbg.n0 VSS 0.14989f $ **FLOATING
C478 Vbg.t5 VSS 0.60909f $ **FLOATING
C479 Vbg.t4 VSS 0.59752f $ **FLOATING
C480 Vbg.n1 VSS 0.08833f $ **FLOATING
C481 Vbg.t1 VSS 0.03775f $ **FLOATING
C482 Vbg.t0 VSS 0.35104f $ **FLOATING
C483 Vbg.n2 VSS 0.0342f $ **FLOATING
C484 Vbg.n3 VSS 1.41343f $ **FLOATING
C485 Vbg.n4 VSS 0.14578f $ **FLOATING
C486 Vbg.n5 VSS 0.90389f $ **FLOATING
C487 Vbg.n6 VSS 9.43938f $ **FLOATING
C488 Vbg.n7 VSS 11.4871f $ **FLOATING
C489 VDD.t0 VSS 0.03576f $ **FLOATING
C490 VDD.n0 VSS 0.23675f $ **FLOATING
C491 VDD.n1 VSS 0.16608f $ **FLOATING
C492 VDD.n2 VSS 0.08227f $ **FLOATING
C493 VDD.n3 VSS 0.08227f $ **FLOATING
C494 VDD.n4 VSS 0.09278f $ **FLOATING
C495 VDD.n5 VSS 0.08227f $ **FLOATING
C496 VDD.n6 VSS 0.08227f $ **FLOATING
C497 VDD.n7 VSS 0.16608f $ **FLOATING
C498 VDD.n8 VSS 0.08227f $ **FLOATING
C499 VDD.n9 VSS 0.08227f $ **FLOATING
C500 VDD.n10 VSS 0.09278f $ **FLOATING
C501 VDD.n11 VSS 0.08227f $ **FLOATING
C502 VDD.n12 VSS 0.08227f $ **FLOATING
C503 VDD.n13 VSS 0.10813f $ **FLOATING
C504 VDD.n14 VSS 0.06599f $ **FLOATING
C505 VDD.n15 VSS 0.06599f $ **FLOATING
C506 VDD.n16 VSS 0.09278f $ **FLOATING
C507 VDD.n17 VSS 0.08227f $ **FLOATING
C508 VDD.n18 VSS 0.08227f $ **FLOATING
C509 VDD.n19 VSS 0.16608f $ **FLOATING
C510 VDD.n20 VSS 0.08227f $ **FLOATING
C511 VDD.n21 VSS 0.08227f $ **FLOATING
C512 VDD.n22 VSS 0.09278f $ **FLOATING
C513 VDD.n23 VSS 0.08227f $ **FLOATING
C514 VDD.n24 VSS 0.08227f $ **FLOATING
C515 VDD.n25 VSS 0.16608f $ **FLOATING
C516 VDD.n26 VSS 0.08227f $ **FLOATING
C517 VDD.n27 VSS 0.08227f $ **FLOATING
C518 VDD.n28 VSS 0.06674f $ **FLOATING
C519 VDD.n29 VSS 2.55114f $ **FLOATING
C520 VDD.n30 VSS 0.16608f $ **FLOATING
C521 VDD.n31 VSS 0.08227f $ **FLOATING
C522 VDD.n32 VSS 0.08227f $ **FLOATING
C523 VDD.n33 VSS 0.2131f $ **FLOATING
C524 VDD.n34 VSS 4.59188f $ **FLOATING
C525 VDD.n35 VSS 0.09278f $ **FLOATING
C526 VDD.n36 VSS 0.08227f $ **FLOATING
C527 VDD.n37 VSS 0.08227f $ **FLOATING
C528 VDD.n38 VSS 0.16608f $ **FLOATING
C529 VDD.n39 VSS 0.16608f $ **FLOATING
C530 VDD.n40 VSS 0.16608f $ **FLOATING
C531 VDD.n41 VSS 0.08227f $ **FLOATING
C532 VDD.n42 VSS 0.08227f $ **FLOATING
C533 VDD.n43 VSS 0.09278f $ **FLOATING
C534 VDD.n44 VSS 0.09278f $ **FLOATING
C535 VDD.n45 VSS 0.09278f $ **FLOATING
C536 VDD.n46 VSS 0.08227f $ **FLOATING
C537 VDD.n47 VSS 0.08227f $ **FLOATING
C538 VDD.n48 VSS 0.16608f $ **FLOATING
C539 VDD.n49 VSS 0.16608f $ **FLOATING
C540 VDD.t3 VSS 0.32544f $ **FLOATING
C541 VDD.t23 VSS 0.21907f $ **FLOATING
C542 VDD.n50 VSS 0.11081f $ **FLOATING
C543 VDD.n51 VSS 0.04671f $ **FLOATING
C544 VDD.t25 VSS 0.21907f $ **FLOATING
C545 VDD.t5 VSS 0.21907f $ **FLOATING
C546 VDD.t9 VSS 0.21907f $ **FLOATING
C547 VDD.t17 VSS 0.21907f $ **FLOATING
C548 VDD.t19 VSS 0.21907f $ **FLOATING
C549 VDD.t28 VSS 0.24485f $ **FLOATING
C550 VDD.t15 VSS 0.35122f $ **FLOATING
C551 VDD.t1 VSS 0.24485f $ **FLOATING
C552 VDD.n52 VSS 0.11892f $ **FLOATING
C553 VDD.t4 VSS 0.24485f $ **FLOATING
C554 VDD.n53 VSS 0.11588f $ **FLOATING
C555 VDD.t16 VSS 0.24485f $ **FLOATING
C556 VDD.n54 VSS 0.11588f $ **FLOATING
C557 VDD.t20 VSS 0.24485f $ **FLOATING
C558 VDD.n55 VSS 0.11588f $ **FLOATING
C559 VDD.t26 VSS 0.24485f $ **FLOATING
C560 VDD.n56 VSS 0.11597f $ **FLOATING
C561 VDD.n57 VSS 0.0981f $ **FLOATING
C562 VDD.t11 VSS 0.35122f $ **FLOATING
C563 VDD.t8 VSS 0.24485f $ **FLOATING
C564 VDD.n58 VSS 0.11892f $ **FLOATING
C565 VDD.t13 VSS 0.24485f $ **FLOATING
C566 VDD.n59 VSS 0.11588f $ **FLOATING
C567 VDD.t12 VSS 0.24485f $ **FLOATING
C568 VDD.n60 VSS 0.11588f $ **FLOATING
C569 VDD.t14 VSS 0.24485f $ **FLOATING
C570 VDD.n61 VSS 0.11588f $ **FLOATING
C571 VDD.t22 VSS 0.24485f $ **FLOATING
C572 VDD.n62 VSS 0.11588f $ **FLOATING
C573 VDD.t2 VSS 0.24485f $ **FLOATING
C574 VDD.n63 VSS 0.08678f $ **FLOATING
C575 VDD.n64 VSS 0.06435f $ **FLOATING
C576 VDD.t6 VSS 0.35122f $ **FLOATING
C577 VDD.t24 VSS 0.24485f $ **FLOATING
C578 VDD.n65 VSS 0.11892f $ **FLOATING
C579 VDD.t27 VSS 0.24485f $ **FLOATING
C580 VDD.n66 VSS 0.11588f $ **FLOATING
C581 VDD.t7 VSS 0.24485f $ **FLOATING
C582 VDD.n67 VSS 0.11588f $ **FLOATING
C583 VDD.t10 VSS 0.24485f $ **FLOATING
C584 VDD.n68 VSS 0.11588f $ **FLOATING
C585 VDD.t18 VSS 0.24485f $ **FLOATING
C586 VDD.n69 VSS 0.11588f $ **FLOATING
C587 VDD.t21 VSS 0.24485f $ **FLOATING
C588 VDD.n70 VSS 0.08678f $ **FLOATING
C589 VDD.n71 VSS 0.06443f $ **FLOATING
C590 VDD.n72 VSS 0.09811f $ **FLOATING
C591 VDD.n73 VSS 0.11588f $ **FLOATING
C592 VDD.n74 VSS 0.11588f $ **FLOATING
C593 VDD.n75 VSS 0.10988f $ **FLOATING
C594 VDD.n76 VSS 0.05062f $ **FLOATING
C595 VDD.n77 VSS 0.03787f $ **FLOATING
C596 VDD.n78 VSS 0.01449f $ **FLOATING
C597 VDD.n79 VSS 1.42964f $ **FLOATING
C598 VDD.n80 VSS 1.32172f $ **FLOATING
C599 VDD.n81 VSS 12.3688f $ **FLOATING
C600 VDD.n82 VSS 0.10813f $ **FLOATING
C601 VDD.n83 VSS 0.06599f $ **FLOATING
C602 VDD.n84 VSS 0.06599f $ **FLOATING
C603 VDD.n85 VSS 6.19772f $ **FLOATING
C604 VDD.n86 VSS 6.19772f $ **FLOATING
C605 VDD.n87 VSS 0.09278f $ **FLOATING
C606 VDD.n88 VSS 0.08227f $ **FLOATING
C607 VDD.n89 VSS 0.08227f $ **FLOATING
C608 VDD.n90 VSS 0.16608f $ **FLOATING
C609 VDD.n91 VSS 0.16608f $ **FLOATING
C610 VDD.n92 VSS 0.16608f $ **FLOATING
C611 VDD.n93 VSS 0.08227f $ **FLOATING
C612 VDD.n94 VSS 0.08227f $ **FLOATING
C613 VDD.n95 VSS 0.09278f $ **FLOATING
C614 VDD.n96 VSS 0.09278f $ **FLOATING
C615 VDD.n97 VSS 0.09278f $ **FLOATING
C616 VDD.n98 VSS 0.08227f $ **FLOATING
C617 VDD.n99 VSS 0.08227f $ **FLOATING
C618 VDD.n100 VSS 0.16608f $ **FLOATING
C619 VDD.n101 VSS 0.16608f $ **FLOATING
C620 VDD.n102 VSS 0.16608f $ **FLOATING
C621 VDD.n103 VSS 0.08227f $ **FLOATING
C622 VDD.n104 VSS 0.08227f $ **FLOATING
C623 VDD.n105 VSS 0.09278f $ **FLOATING
C624 VDD.n106 VSS 0.09278f $ **FLOATING
C625 VDD.n107 VSS 1.34393f $ **FLOATING
C626 VDD.n108 VSS 0.06599f $ **FLOATING
C627 VDD.n109 VSS 0.06599f $ **FLOATING
C628 VDD.n110 VSS 0.10813f $ **FLOATING
C629 VDD.n111 VSS 0.59927f $ **FLOATING
C630 ldo_brahim_0.ldo_brahim_pass_element2_0.VG2.t5 VSS 0.11444f $ **FLOATING
C631 ldo_brahim_0.ldo_brahim_pass_element2_0.VG2.n0 VSS 0.02912f $ **FLOATING
C632 ldo_brahim_0.ldo_brahim_pass_element2_0.VG2.t9 VSS 0.14115f $ **FLOATING
C633 ldo_brahim_0.ldo_brahim_pass_element2_0.VG2.t8 VSS 0.14114f $ **FLOATING
C634 ldo_brahim_0.ldo_brahim_pass_element2_0.VG2.t6 VSS 0.14114f $ **FLOATING
C635 ldo_brahim_0.ldo_brahim_pass_element2_0.VG2.t7 VSS 0.14115f $ **FLOATING
C636 ldo_brahim_0.ldo_brahim_pass_element2_0.VG2.n1 VSS 0.08468f $ **FLOATING
C637 ldo_brahim_0.ldo_brahim_pass_element2_0.VG2.n2 VSS 0.09421f $ **FLOATING
C638 ldo_brahim_0.ldo_brahim_pass_element2_0.VG2.n3 VSS 0.08857f $ **FLOATING
C639 ldo_brahim_0.ldo_brahim_pass_element2_0.VG2.n4 VSS 0.05618f $ **FLOATING
C640 ldo_brahim_0.ldo_brahim_pass_element2_0.VG2.n5 VSS 0.03688f $ **FLOATING
C641 ldo_brahim_0.ldo_brahim_pass_element2_0.VG2.n6 VSS 0.26584f $ **FLOATING
C642 ldo_brahim_0.ldo_brahim_pass_element2_0.VG2.n7 VSS 0.15354f $ **FLOATING
C643 ldo_brahim_0.ldo_brahim_pass_element2_0.VG2.n8 VSS 0.13412f $ **FLOATING
C644 ldo_brahim_0.ldo_brahim_pass_element2_0.VG2.n9 VSS 0.01333f $ **FLOATING
C645 ldo_brahim_0.ldo_brahim_pass_element2_0.VG2.n10 VSS 0.01333f $ **FLOATING
C646 ldo_brahim_0.ldo_brahim_pass_element2_0.VG2.n11 VSS 0.01333f $ **FLOATING
C647 ldo_brahim_0.ldo_brahim_pass_element2_0.VG2.n12 VSS 0.02448f $ **FLOATING
C648 ldo_brahim_0.ldo_brahim_pass_element2_0.VG2.n13 VSS 0.0212f $ **FLOATING
C649 ldo_brahim_0.ldo_brahim_pass_element2_0.VG2.n14 VSS 0.16758f $ **FLOATING
C650 ldo_brahim_0.ldo_brahim_pass_element2_0.VG2.n15 VSS 0.01934f $ **FLOATING
C651 ldo_brahim_0.ldo_brahim_pass_element2_0.VG2.n16 VSS 0.01934f $ **FLOATING
C652 ldo_brahim_0.ldo_brahim_pass_element2_0.VG2.n17 VSS 0.11095f $ **FLOATING
C653 ldo_brahim_0.ldo_brahim_pass_element2_0.VG2.n18 VSS 0.01934f $ **FLOATING
C654 ldo_brahim_0.ldo_brahim_pass_element2_0.VG2.n19 VSS 0.01934f $ **FLOATING
C655 ldo_brahim_0.ldo_brahim_pass_element2_0.VG2.n20 VSS 0.16513f $ **FLOATING
C656 ldo_brahim_0.ldo_brahim_pass_element2_0.VG2.n21 VSS 0.16784f $ **FLOATING
C657 ldo_brahim_0.ldo_brahim_pass_element2_0.VG2.n23 VSS 0.30748f $ **FLOATING
C658 ldo_brahim_0.ldo_brahim_pass_element2_0.VG2.n24 VSS 0.10848f $ **FLOATING
C659 ldo_brahim_0.ldo_brahim_pass_element2_0.VG2.n25 VSS 0.1702f $ **FLOATING
C660 ldo_brahim_0.ldo_brahim_pass_element2_0.VG2.n26 VSS 0.16995f $ **FLOATING
C661 ldo_brahim_0.ldo_brahim_pass_element2_0.VG2.n27 VSS 0.16982f $ **FLOATING
C662 ldo_brahim_0.ldo_brahim_pass_element2_0.VG2.n28 VSS 0.16325f $ **FLOATING
C663 ldo_brahim_0.ldo_brahim_pass_element2_0.VG2.n29 VSS 0.19202f $ **FLOATING
C664 ldo_brahim_0.ldo_brahim_pass_element2_0.VG2.n30 VSS 0.18941f $ **FLOATING
C665 ldo_brahim_0.ldo_brahim_pass_element2_0.VG2.n31 VSS 0.18928f $ **FLOATING
C666 ldo_brahim_0.ldo_brahim_pass_element2_0.VG2.n32 VSS 0.19177f $ **FLOATING
C667 ldo_brahim_0.ldo_brahim_pass_element2_0.VG2.n33 VSS 0.02002f $ **FLOATING
C668 ldo_brahim_0.ldo_brahim_pass_element2_0.VG2.t10 VSS 9.54075f $ **FLOATING
C669 ldo_brahim_0.ldo_brahim_pass_element2_0.VG2.n34 VSS 0.03228f $ **FLOATING
C670 ldo_brahim_0.ldo_brahim_pass_element2_0.VG2.n35 VSS 0.11219f $ **FLOATING
C671 ldo_brahim_0.ldo_brahim_pass_element2_0.VG2.t4 VSS 48.2644f $ **FLOATING
C672 ldo_brahim_0.ldo_brahim_pass_element2_0.VG2.n36 VSS 0.22452f $ **FLOATING
C673 ldo_brahim_0.ldo_brahim_pass_element2_0.VG2.t2 VSS 0.14127f $ **FLOATING
C674 ldo_brahim_0.ldo_brahim_pass_element2_0.VG2.t1 VSS 0.17647f $ **FLOATING
C675 ldo_brahim_0.ldo_brahim_pass_element2_0.VG2.t0 VSS 0.20639f $ **FLOATING
C676 ldo_brahim_0.ldo_brahim_pass_element2_0.VG2.n37 VSS 0.1285f $ **FLOATING
C677 ldo_brahim_0.ldo_brahim_pass_element2_0.VG2.n38 VSS 0.13514f $ **FLOATING
C678 ldo_brahim_0.ldo_brahim_pass_element2_0.VG2.t3 VSS 0.14104f $ **FLOATING
C679 ldo_brahim_0.ldo_brahim_pass_element2_0.VG2.n39 VSS 0.08892f $ **FLOATING
C680 ldo_brahim_0.ldo_brahim_pass_element2_0.VG2.n40 VSS 0.05158f $ **FLOATING
C681 bgr_djalal_0.bgr_djalal_ota_1_stage_0.Vout1.t3 VSS 0.11817f $ **FLOATING
C682 bgr_djalal_0.bgr_djalal_ota_1_stage_0.Vout1.t2 VSS 0.0298f $ **FLOATING
C683 bgr_djalal_0.bgr_djalal_ota_1_stage_0.Vout1.n0 VSS 0.28095f $ **FLOATING
C684 bgr_djalal_0.bgr_djalal_ota_1_stage_0.Vout1.t11 VSS 2.37458f $ **FLOATING
C685 bgr_djalal_0.bgr_djalal_ota_1_stage_0.Vout1.t9 VSS 3.58761f $ **FLOATING
C686 bgr_djalal_0.bgr_djalal_ota_1_stage_0.Vout1.t10 VSS 3.58761f $ **FLOATING
C687 bgr_djalal_0.bgr_djalal_ota_1_stage_0.Vout1.t6 VSS 15.5463f $ **FLOATING
C688 bgr_djalal_0.bgr_djalal_ota_1_stage_0.Vout1.t7 VSS 14.8895f $ **FLOATING
C689 bgr_djalal_0.bgr_djalal_ota_1_stage_0.Vout1.t8 VSS 14.8895f $ **FLOATING
C690 bgr_djalal_0.bgr_djalal_ota_1_stage_0.Vout1.t5 VSS 15.5693f $ **FLOATING
C691 bgr_djalal_0.bgr_djalal_ota_1_stage_0.Vout1.n1 VSS 0.26636f $ **FLOATING
C692 bgr_djalal_0.bgr_djalal_ota_1_stage_0.Vout1.t4 VSS 0.18733f $ **FLOATING
C693 bgr_djalal_0.bgr_djalal_ota_1_stage_0.Vout1.n2 VSS 0.45147f $ **FLOATING
C694 bgr_djalal_0.bgr_djalal_ota_1_stage_0.Vout1.n3 VSS 0.14735f $ **FLOATING
C695 bgr_djalal_0.bgr_djalal_ota_1_stage_0.Vout1.t1 VSS 0.24301f $ **FLOATING
C696 bgr_djalal_0.bgr_djalal_ota_1_stage_0.Vout1.t0 VSS 0.5307f $ **FLOATING
C697 bgr_djalal_0.bgr_djalal_ota_1_stage_0.Vout1.n4 VSS 0.38302f $ **FLOATING
C698 bgr_djalal_0.bgr_djalal_ota_1_stage_0.Vout1.n5 VSS 0.09911f $ **FLOATING
C699 ldo_brahim_0.ldo_brahim_opamp_2_stage_0/ldo_brahim_tail_0.tail.t2 VSS 0.37338f $ **FLOATING
C700 ldo_brahim_0.ldo_brahim_opamp_2_stage_0/ldo_brahim_tail_0.tail.t1 VSS 0.4375f $ **FLOATING
C701 ldo_brahim_0.ldo_brahim_opamp_2_stage_0/ldo_brahim_tail_0.tail.n0 VSS 0.19502f $ **FLOATING
C702 ldo_brahim_0.ldo_brahim_opamp_2_stage_0/ldo_brahim_tail_0.tail.n1 VSS 0.17102f $ **FLOATING
C703 ldo_brahim_0.ldo_brahim_opamp_2_stage_0/ldo_brahim_tail_0.tail.n2 VSS 0.06538f $ **FLOATING
C704 ldo_brahim_0.ldo_brahim_opamp_2_stage_0/ldo_brahim_tail_0.tail.n3 VSS 0.01344f $ **FLOATING
C705 ldo_brahim_0.ldo_brahim_opamp_2_stage_0/ldo_brahim_tail_0.tail.n4 VSS 0.01344f $ **FLOATING
C706 ldo_brahim_0.ldo_brahim_opamp_2_stage_0/ldo_brahim_tail_0.tail.n5 VSS 0.02707f $ **FLOATING
C707 ldo_brahim_0.ldo_brahim_opamp_2_stage_0/ldo_brahim_tail_0.tail.n6 VSS 0.02707f $ **FLOATING
C708 ldo_brahim_0.ldo_brahim_opamp_2_stage_0/ldo_brahim_tail_0.tail.n7 VSS 0.02689f $ **FLOATING
C709 ldo_brahim_0.ldo_brahim_opamp_2_stage_0/ldo_brahim_tail_0.tail.n8 VSS 0.02707f $ **FLOATING
C710 ldo_brahim_0.ldo_brahim_opamp_2_stage_0/ldo_brahim_tail_0.tail.n9 VSS 0.02689f $ **FLOATING
C711 ldo_brahim_0.ldo_brahim_opamp_2_stage_0/ldo_brahim_tail_0.tail.n10 VSS 0.02688f $ **FLOATING
C712 ldo_brahim_0.ldo_brahim_opamp_2_stage_0/ldo_brahim_tail_0.tail.t5 VSS 0.14785f $ **FLOATING
C713 ldo_brahim_0.ldo_brahim_opamp_2_stage_0/ldo_brahim_tail_0.tail.t4 VSS 0.14791f $ **FLOATING
C714 ldo_brahim_0.ldo_brahim_opamp_2_stage_0/ldo_brahim_tail_0.tail.n11 VSS 0.33811f $ **FLOATING
C715 ldo_brahim_0.ldo_brahim_opamp_2_stage_0/ldo_brahim_tail_0.tail.n12 VSS 0.15716f $ **FLOATING
C716 ldo_brahim_0.ldo_brahim_opamp_2_stage_0/ldo_brahim_tail_0.tail.t3 VSS 0.13375f $ **FLOATING
C717 ldo_brahim_0.ldo_brahim_opamp_2_stage_0/ldo_brahim_tail_0.tail.n13 VSS 0.02707f $ **FLOATING
C718 ldo_brahim_0.ldo_brahim_opamp_2_stage_0/ldo_brahim_tail_0.tail.n14 VSS 0.02707f $ **FLOATING
C719 ldo_brahim_0.ldo_brahim_opamp_2_stage_0/ldo_brahim_tail_0.tail.t0 VSS 0.13375f $ **FLOATING
C720 ldo_brahim_0.ldo_brahim_opamp_2_stage_0/ldo_brahim_tail_0.tail.n15 VSS 0.01456f $ **FLOATING
C721 ldo_brahim_0.ldo_brahim_opamp_2_stage_0/ldo_brahim_tail_0.tail.n16 VSS 0.05838f $ **FLOATING
C722 IOVDD.n0 VSS 0.01314f $ **FLOATING
C723 IOVDD.n1 VSS 0.08088f $ **FLOATING
C724 IOVDD.n3 VSS 0.02635f $ **FLOATING
C725 IOVDD.n4 VSS 0.02637f $ **FLOATING
C726 IOVDD.n5 VSS 0.018f $ **FLOATING
C727 IOVDD.n6 VSS 0.018f $ **FLOATING
C728 IOVDD.n7 VSS 0.018f $ **FLOATING
C729 IOVDD.n8 VSS 0.01825f $ **FLOATING
C730 IOVDD.n9 VSS 0.018f $ **FLOATING
C731 IOVDD.n10 VSS 0.018f $ **FLOATING
C732 IOVDD.n11 VSS 0.01825f $ **FLOATING
C733 IOVDD.n12 VSS 0.018f $ **FLOATING
C734 IOVDD.n13 VSS 0.018f $ **FLOATING
C735 IOVDD.n14 VSS 0.01825f $ **FLOATING
C736 IOVDD.n15 VSS 0.018f $ **FLOATING
C737 IOVDD.n16 VSS 0.018f $ **FLOATING
C738 IOVDD.t121 VSS 0.04658f $ **FLOATING
C739 IOVDD.t2 VSS 0.04658f $ **FLOATING
C740 IOVDD.n18 VSS 0.0331f $ **FLOATING
C741 IOVDD.n19 VSS 0.017f $ **FLOATING
C742 IOVDD.n20 VSS 0.017f $ **FLOATING
C743 IOVDD.n21 VSS 0.017f $ **FLOATING
C744 IOVDD.n22 VSS 0.017f $ **FLOATING
C745 IOVDD.n23 VSS 0.017f $ **FLOATING
C746 IOVDD.n24 VSS 0.17005f $ **FLOATING
C747 IOVDD.n25 VSS 0.017f $ **FLOATING
C748 IOVDD.n26 VSS 0.017f $ **FLOATING
C749 IOVDD.n27 VSS 0.017f $ **FLOATING
C750 IOVDD.n28 VSS 0.017f $ **FLOATING
C751 IOVDD.n29 VSS 0.017f $ **FLOATING
C752 IOVDD.n30 VSS 0.017f $ **FLOATING
C753 IOVDD.t120 VSS 0.04658f $ **FLOATING
C754 IOVDD.n31 VSS 0.03401f $ **FLOATING
C755 IOVDD.n32 VSS 0.02701f $ **FLOATING
C756 IOVDD.n33 VSS 0.017f $ **FLOATING
C757 IOVDD.n34 VSS 0.019f $ **FLOATING
C758 IOVDD.t119 VSS 0.29431f $ **FLOATING
C759 IOVDD.n35 VSS 0.03024f $ **FLOATING
C760 IOVDD.n36 VSS 0.01277f $ **FLOATING
C761 IOVDD.n37 VSS 0.018f $ **FLOATING
C762 IOVDD.n38 VSS 0.018f $ **FLOATING
C763 IOVDD.n39 VSS 0.018f $ **FLOATING
C764 IOVDD.n40 VSS 0.01825f $ **FLOATING
C765 IOVDD.n41 VSS 0.018f $ **FLOATING
C766 IOVDD.n42 VSS 0.018f $ **FLOATING
C767 IOVDD.n43 VSS 0.01825f $ **FLOATING
C768 IOVDD.n44 VSS 0.018f $ **FLOATING
C769 IOVDD.n45 VSS 0.018f $ **FLOATING
C770 IOVDD.n46 VSS 0.01825f $ **FLOATING
C771 IOVDD.n47 VSS 0.018f $ **FLOATING
C772 IOVDD.n48 VSS 0.018f $ **FLOATING
C773 IOVDD.n49 VSS 0.01825f $ **FLOATING
C774 IOVDD.t150 VSS 0.04658f $ **FLOATING
C775 IOVDD.t28 VSS 0.04658f $ **FLOATING
C776 IOVDD.n50 VSS 0.017f $ **FLOATING
C777 IOVDD.n51 VSS 0.017f $ **FLOATING
C778 IOVDD.n52 VSS 0.017f $ **FLOATING
C779 IOVDD.n53 VSS 0.017f $ **FLOATING
C780 IOVDD.n54 VSS 0.017f $ **FLOATING
C781 IOVDD.n55 VSS 0.017f $ **FLOATING
C782 IOVDD.n56 VSS 0.03401f $ **FLOATING
C783 IOVDD.n57 VSS 0.017f $ **FLOATING
C784 IOVDD.n58 VSS 0.017f $ **FLOATING
C785 IOVDD.n59 VSS 0.017f $ **FLOATING
C786 IOVDD.n60 VSS 0.017f $ **FLOATING
C787 IOVDD.n61 VSS 0.017f $ **FLOATING
C788 IOVDD.n62 VSS 0.017f $ **FLOATING
C789 IOVDD.t151 VSS 0.04658f $ **FLOATING
C790 IOVDD.n63 VSS 0.05609f $ **FLOATING
C791 IOVDD.n64 VSS 0.03798f $ **FLOATING
C792 IOVDD.n65 VSS 0.09693f $ **FLOATING
C793 IOVDD.n66 VSS 0.02926f $ **FLOATING
C794 IOVDD.n67 VSS 0.018f $ **FLOATING
C795 IOVDD.n68 VSS 0.018f $ **FLOATING
C796 IOVDD.n69 VSS 0.018f $ **FLOATING
C797 IOVDD.n70 VSS 0.01825f $ **FLOATING
C798 IOVDD.n71 VSS 0.018f $ **FLOATING
C799 IOVDD.n72 VSS 0.018f $ **FLOATING
C800 IOVDD.n73 VSS 0.01825f $ **FLOATING
C801 IOVDD.n74 VSS 0.018f $ **FLOATING
C802 IOVDD.n75 VSS 0.018f $ **FLOATING
C803 IOVDD.n76 VSS 0.01825f $ **FLOATING
C804 IOVDD.n77 VSS 0.018f $ **FLOATING
C805 IOVDD.n78 VSS 0.018f $ **FLOATING
C806 IOVDD.t29 VSS 0.04658f $ **FLOATING
C807 IOVDD.t139 VSS 0.04658f $ **FLOATING
C808 IOVDD.n80 VSS 0.0331f $ **FLOATING
C809 IOVDD.n81 VSS 0.017f $ **FLOATING
C810 IOVDD.n82 VSS 0.017f $ **FLOATING
C811 IOVDD.n83 VSS 0.017f $ **FLOATING
C812 IOVDD.n84 VSS 0.017f $ **FLOATING
C813 IOVDD.n85 VSS 0.017f $ **FLOATING
C814 IOVDD.n86 VSS 0.17015f $ **FLOATING
C815 IOVDD.n87 VSS 0.017f $ **FLOATING
C816 IOVDD.n88 VSS 0.017f $ **FLOATING
C817 IOVDD.n89 VSS 0.017f $ **FLOATING
C818 IOVDD.n90 VSS 0.017f $ **FLOATING
C819 IOVDD.n91 VSS 0.017f $ **FLOATING
C820 IOVDD.n92 VSS 0.017f $ **FLOATING
C821 IOVDD.t140 VSS 0.04658f $ **FLOATING
C822 IOVDD.n93 VSS 0.03401f $ **FLOATING
C823 IOVDD.n94 VSS 0.02701f $ **FLOATING
C824 IOVDD.n95 VSS 0.017f $ **FLOATING
C825 IOVDD.n96 VSS 0.019f $ **FLOATING
C826 IOVDD.t39 VSS 0.29431f $ **FLOATING
C827 IOVDD.n97 VSS 0.03024f $ **FLOATING
C828 IOVDD.n98 VSS 0.01277f $ **FLOATING
C829 IOVDD.n99 VSS 0.018f $ **FLOATING
C830 IOVDD.n100 VSS 0.018f $ **FLOATING
C831 IOVDD.n101 VSS 0.018f $ **FLOATING
C832 IOVDD.n102 VSS 0.01825f $ **FLOATING
C833 IOVDD.n103 VSS 0.018f $ **FLOATING
C834 IOVDD.n104 VSS 0.018f $ **FLOATING
C835 IOVDD.n105 VSS 0.01825f $ **FLOATING
C836 IOVDD.n106 VSS 0.018f $ **FLOATING
C837 IOVDD.n107 VSS 0.018f $ **FLOATING
C838 IOVDD.n108 VSS 0.01825f $ **FLOATING
C839 IOVDD.n109 VSS 0.018f $ **FLOATING
C840 IOVDD.n110 VSS 0.018f $ **FLOATING
C841 IOVDD.n111 VSS 0.01825f $ **FLOATING
C842 IOVDD.t41 VSS 0.04658f $ **FLOATING
C843 IOVDD.t40 VSS 0.04658f $ **FLOATING
C844 IOVDD.n112 VSS 0.017f $ **FLOATING
C845 IOVDD.n113 VSS 0.017f $ **FLOATING
C846 IOVDD.n114 VSS 0.017f $ **FLOATING
C847 IOVDD.n115 VSS 0.017f $ **FLOATING
C848 IOVDD.n116 VSS 0.017f $ **FLOATING
C849 IOVDD.n117 VSS 0.017f $ **FLOATING
C850 IOVDD.n118 VSS 0.03401f $ **FLOATING
C851 IOVDD.n119 VSS 0.017f $ **FLOATING
C852 IOVDD.n120 VSS 0.017f $ **FLOATING
C853 IOVDD.n121 VSS 0.017f $ **FLOATING
C854 IOVDD.n122 VSS 0.017f $ **FLOATING
C855 IOVDD.n123 VSS 0.017f $ **FLOATING
C856 IOVDD.n124 VSS 0.017f $ **FLOATING
C857 IOVDD.t30 VSS 0.04658f $ **FLOATING
C858 IOVDD.n125 VSS 0.05554f $ **FLOATING
C859 IOVDD.n126 VSS 0.03929f $ **FLOATING
C860 IOVDD.n127 VSS 0.08287f $ **FLOATING
C861 IOVDD.n128 VSS 0.03337f $ **FLOATING
C862 IOVDD.n129 VSS 0.41466f $ **FLOATING
C863 IOVDD.n135 VSS 0.01827f $ **FLOATING
C864 IOVDD.n136 VSS 0.02053f $ **FLOATING
C865 IOVDD.n137 VSS 0.01495f $ **FLOATING
C866 IOVDD.t95 VSS 0.04658f $ **FLOATING
C867 IOVDD.n138 VSS 0.01412f $ **FLOATING
C868 IOVDD.n139 VSS 0.01412f $ **FLOATING
C869 IOVDD.n140 VSS 0.01412f $ **FLOATING
C870 IOVDD.n141 VSS 0.01412f $ **FLOATING
C871 IOVDD.n142 VSS 0.01412f $ **FLOATING
C872 IOVDD.n143 VSS 0.01412f $ **FLOATING
C873 IOVDD.n144 VSS 0.01495f $ **FLOATING
C874 IOVDD.n145 VSS 0.01412f $ **FLOATING
C875 IOVDD.n146 VSS 0.01515f $ **FLOATING
C876 IOVDD.n147 VSS 0.01495f $ **FLOATING
C877 IOVDD.n148 VSS 0.01412f $ **FLOATING
C878 IOVDD.n149 VSS 0.01495f $ **FLOATING
C879 IOVDD.n150 VSS 0.01495f $ **FLOATING
C880 IOVDD.n151 VSS 0.01412f $ **FLOATING
C881 IOVDD.n152 VSS 0.01495f $ **FLOATING
C882 IOVDD.n153 VSS 0.01515f $ **FLOATING
C883 IOVDD.n154 VSS 0.01412f $ **FLOATING
C884 IOVDD.n155 VSS 0.01515f $ **FLOATING
C885 IOVDD.n156 VSS 0.01495f $ **FLOATING
C886 IOVDD.n157 VSS 0.01412f $ **FLOATING
C887 IOVDD.n158 VSS 0.01495f $ **FLOATING
C888 IOVDD.n159 VSS 0.01495f $ **FLOATING
C889 IOVDD.n160 VSS 0.01412f $ **FLOATING
C890 IOVDD.n161 VSS 0.01515f $ **FLOATING
C891 IOVDD.n162 VSS 0.01412f $ **FLOATING
C892 IOVDD.t124 VSS 0.04658f $ **FLOATING
C893 IOVDD.t123 VSS 0.04658f $ **FLOATING
C894 IOVDD.n163 VSS 0.1368f $ **FLOATING
C895 IOVDD.n164 VSS 0.01515f $ **FLOATING
C896 IOVDD.n165 VSS 0.01412f $ **FLOATING
C897 IOVDD.n166 VSS 0.01495f $ **FLOATING
C898 IOVDD.n167 VSS 0.01412f $ **FLOATING
C899 IOVDD.n168 VSS 0.01495f $ **FLOATING
C900 IOVDD.n169 VSS 0.01412f $ **FLOATING
C901 IOVDD.n170 VSS 0.01515f $ **FLOATING
C902 IOVDD.n171 VSS 0.01412f $ **FLOATING
C903 IOVDD.n172 VSS 0.01495f $ **FLOATING
C904 IOVDD.n173 VSS 0.01412f $ **FLOATING
C905 IOVDD.n174 VSS 0.01495f $ **FLOATING
C906 IOVDD.n175 VSS 0.01412f $ **FLOATING
C907 IOVDD.n176 VSS 0.01515f $ **FLOATING
C908 IOVDD.n177 VSS 0.01412f $ **FLOATING
C909 IOVDD.n178 VSS 0.01495f $ **FLOATING
C910 IOVDD.n179 VSS 0.01412f $ **FLOATING
C911 IOVDD.n180 VSS 0.01495f $ **FLOATING
C912 IOVDD.n181 VSS 0.01412f $ **FLOATING
C913 IOVDD.n182 VSS 0.01515f $ **FLOATING
C914 IOVDD.n183 VSS 0.01412f $ **FLOATING
C915 IOVDD.n184 VSS 0.01495f $ **FLOATING
C916 IOVDD.n185 VSS 0.01412f $ **FLOATING
C917 IOVDD.n186 VSS 0.01495f $ **FLOATING
C918 IOVDD.n187 VSS 0.02759f $ **FLOATING
C919 IOVDD.n189 VSS 0.02823f $ **FLOATING
C920 IOVDD.n190 VSS 0.02366f $ **FLOATING
C921 IOVDD.n191 VSS 0.01412f $ **FLOATING
C922 IOVDD.t94 VSS 0.29623f $ **FLOATING
C923 IOVDD.n192 VSS 0.02926f $ **FLOATING
C924 IOVDD.n193 VSS 0.01267f $ **FLOATING
C925 IOVDD.n194 VSS 0.02823f $ **FLOATING
C926 IOVDD.t96 VSS 0.04658f $ **FLOATING
C927 IOVDD.n195 VSS 0.13661f $ **FLOATING
C928 IOVDD.n196 VSS 0.02078f $ **FLOATING
C929 IOVDD.n197 VSS 0.01495f $ **FLOATING
C930 IOVDD.t145 VSS 0.04658f $ **FLOATING
C931 IOVDD.n198 VSS 0.02745f $ **FLOATING
C932 IOVDD.n199 VSS 0.01412f $ **FLOATING
C933 IOVDD.n200 VSS 0.01412f $ **FLOATING
C934 IOVDD.n201 VSS 0.01412f $ **FLOATING
C935 IOVDD.n202 VSS 0.01412f $ **FLOATING
C936 IOVDD.n203 VSS 0.01412f $ **FLOATING
C937 IOVDD.n204 VSS 0.01495f $ **FLOATING
C938 IOVDD.n205 VSS 0.01412f $ **FLOATING
C939 IOVDD.n206 VSS 0.01515f $ **FLOATING
C940 IOVDD.n207 VSS 0.01495f $ **FLOATING
C941 IOVDD.n208 VSS 0.01412f $ **FLOATING
C942 IOVDD.n209 VSS 0.01495f $ **FLOATING
C943 IOVDD.n210 VSS 0.01495f $ **FLOATING
C944 IOVDD.n211 VSS 0.01412f $ **FLOATING
C945 IOVDD.n212 VSS 0.01495f $ **FLOATING
C946 IOVDD.n213 VSS 0.01515f $ **FLOATING
C947 IOVDD.n214 VSS 0.01412f $ **FLOATING
C948 IOVDD.n215 VSS 0.01515f $ **FLOATING
C949 IOVDD.n216 VSS 0.01495f $ **FLOATING
C950 IOVDD.n217 VSS 0.01412f $ **FLOATING
C951 IOVDD.n218 VSS 0.01495f $ **FLOATING
C952 IOVDD.n219 VSS 0.01495f $ **FLOATING
C953 IOVDD.n220 VSS 0.01412f $ **FLOATING
C954 IOVDD.n221 VSS 0.01412f $ **FLOATING
C955 IOVDD.n222 VSS 0.01495f $ **FLOATING
C956 IOVDD.t175 VSS 0.04658f $ **FLOATING
C957 IOVDD.n223 VSS 0.01412f $ **FLOATING
C958 IOVDD.n224 VSS 0.01412f $ **FLOATING
C959 IOVDD.n225 VSS 0.01412f $ **FLOATING
C960 IOVDD.n226 VSS 0.01412f $ **FLOATING
C961 IOVDD.n227 VSS 0.01412f $ **FLOATING
C962 IOVDD.n228 VSS 0.01412f $ **FLOATING
C963 IOVDD.n229 VSS 0.01495f $ **FLOATING
C964 IOVDD.n230 VSS 0.01412f $ **FLOATING
C965 IOVDD.n231 VSS 0.01515f $ **FLOATING
C966 IOVDD.n232 VSS 0.01495f $ **FLOATING
C967 IOVDD.n233 VSS 0.01412f $ **FLOATING
C968 IOVDD.n234 VSS 0.01495f $ **FLOATING
C969 IOVDD.n235 VSS 0.01495f $ **FLOATING
C970 IOVDD.n236 VSS 0.01412f $ **FLOATING
C971 IOVDD.n237 VSS 0.01495f $ **FLOATING
C972 IOVDD.n238 VSS 0.01515f $ **FLOATING
C973 IOVDD.n239 VSS 0.01412f $ **FLOATING
C974 IOVDD.n240 VSS 0.01515f $ **FLOATING
C975 IOVDD.n241 VSS 0.01495f $ **FLOATING
C976 IOVDD.n242 VSS 0.01412f $ **FLOATING
C977 IOVDD.n243 VSS 0.01495f $ **FLOATING
C978 IOVDD.n244 VSS 0.01495f $ **FLOATING
C979 IOVDD.n245 VSS 0.01412f $ **FLOATING
C980 IOVDD.n246 VSS 0.03429f $ **FLOATING
C981 IOVDD.n247 VSS 0.04604f $ **FLOATING
C982 IOVDD.n248 VSS 0.03499f $ **FLOATING
C983 IOVDD.n249 VSS 0.03499f $ **FLOATING
C984 IOVDD.n250 VSS 0.03499f $ **FLOATING
C985 IOVDD.n251 VSS 0.03499f $ **FLOATING
C986 IOVDD.n252 VSS 0.03946f $ **FLOATING
C987 IOVDD.n253 VSS 0.03499f $ **FLOATING
C988 IOVDD.n254 VSS 0.03499f $ **FLOATING
C989 IOVDD.n255 VSS 0.02825f $ **FLOATING
C990 IOVDD.n256 VSS 0.03946f $ **FLOATING
C991 IOVDD.n257 VSS 0.03499f $ **FLOATING
C992 IOVDD.n258 VSS 0.08445f $ **FLOATING
C993 IOVDD.n259 VSS 0.03499f $ **FLOATING
C994 IOVDD.n260 VSS 0.03499f $ **FLOATING
C995 IOVDD.n261 VSS 0.03499f $ **FLOATING
C996 IOVDD.n262 VSS 0.03946f $ **FLOATING
C997 IOVDD.n263 VSS 0.03499f $ **FLOATING
C998 IOVDD.n264 VSS 0.03499f $ **FLOATING
C999 IOVDD.n266 VSS 0.1321f $ **FLOATING
C1000 IOVDD.n267 VSS 0.03499f $ **FLOATING
C1001 IOVDD.n268 VSS 0.03946f $ **FLOATING
C1002 IOVDD.n269 VSS 0.03499f $ **FLOATING
C1003 IOVDD.n270 VSS 0.03499f $ **FLOATING
C1004 IOVDD.n271 VSS 0.04472f $ **FLOATING
C1005 IOVDD.n273 VSS 0.02141f $ **FLOATING
C1006 IOVDD.n276 VSS 0.02172f $ **FLOATING
C1007 IOVDD.n277 VSS 0.02141f $ **FLOATING
C1008 IOVDD.n278 VSS 0.02141f $ **FLOATING
C1009 IOVDD.n279 VSS 0.02141f $ **FLOATING
C1010 IOVDD.n280 VSS 0.02141f $ **FLOATING
C1011 IOVDD.n281 VSS 0.02141f $ **FLOATING
C1012 IOVDD.n282 VSS 0.02141f $ **FLOATING
C1013 IOVDD.n283 VSS 0.02141f $ **FLOATING
C1014 IOVDD.n284 VSS 0.02141f $ **FLOATING
C1015 IOVDD.n285 VSS 0.02141f $ **FLOATING
C1016 IOVDD.n286 VSS 0.02141f $ **FLOATING
C1017 IOVDD.n287 VSS 0.02141f $ **FLOATING
C1018 IOVDD.n288 VSS 0.02141f $ **FLOATING
C1019 IOVDD.n289 VSS 0.02141f $ **FLOATING
C1020 IOVDD.n290 VSS 0.02141f $ **FLOATING
C1021 IOVDD.n291 VSS 0.02141f $ **FLOATING
C1022 IOVDD.n292 VSS 0.02141f $ **FLOATING
C1023 IOVDD.n293 VSS 0.02141f $ **FLOATING
C1024 IOVDD.n294 VSS 0.02141f $ **FLOATING
C1025 IOVDD.n295 VSS 0.04057f $ **FLOATING
C1026 IOVDD.n296 VSS 0.04495f $ **FLOATING
C1027 IOVDD.n298 VSS 0.01102f $ **FLOATING
C1028 IOVDD.n299 VSS 0.02141f $ **FLOATING
C1029 IOVDD.n300 VSS 0.02141f $ **FLOATING
C1030 IOVDD.n301 VSS 0.02141f $ **FLOATING
C1031 IOVDD.n302 VSS 0.02141f $ **FLOATING
C1032 IOVDD.n303 VSS 0.02141f $ **FLOATING
C1033 IOVDD.n304 VSS 0.02204f $ **FLOATING
C1034 IOVDD.n305 VSS 0.02172f $ **FLOATING
C1035 IOVDD.n315 VSS 0.02172f $ **FLOATING
C1036 IOVDD.n316 VSS 0.02172f $ **FLOATING
C1037 IOVDD.n319 VSS 0.02203f $ **FLOATING
C1038 IOVDD.n320 VSS 0.02172f $ **FLOATING
C1039 IOVDD.n323 VSS 0.02172f $ **FLOATING
C1040 IOVDD.n324 VSS 0.02203f $ **FLOATING
C1041 IOVDD.n327 VSS 0.02172f $ **FLOATING
C1042 IOVDD.n328 VSS 0.02172f $ **FLOATING
C1043 IOVDD.n332 VSS 0.02172f $ **FLOATING
C1044 IOVDD.n333 VSS 0.02204f $ **FLOATING
C1045 IOVDD.n336 VSS 0.02172f $ **FLOATING
C1046 IOVDD.n337 VSS 0.02172f $ **FLOATING
C1047 IOVDD.n340 VSS 0.02172f $ **FLOATING
C1048 IOVDD.n341 VSS 0.02203f $ **FLOATING
C1049 IOVDD.n344 VSS 0.02172f $ **FLOATING
C1050 IOVDD.n345 VSS 0.02172f $ **FLOATING
C1051 IOVDD.n348 VSS 0.02203f $ **FLOATING
C1052 IOVDD.n349 VSS 0.02172f $ **FLOATING
C1053 IOVDD.n352 VSS 0.02172f $ **FLOATING
C1054 IOVDD.n353 VSS 0.02172f $ **FLOATING
C1055 IOVDD.n358 VSS 0.18373f $ **FLOATING
C1056 IOVDD.n360 VSS 0.70185f $ **FLOATING
C1057 IOVDD.t33 VSS 8.77349f $ **FLOATING
C1058 IOVDD.t156 VSS 1.05277f $ **FLOATING
C1059 IOVDD.n361 VSS 0.70185f $ **FLOATING
C1060 IOVDD.n362 VSS 0.70185f $ **FLOATING
C1061 IOVDD.t130 VSS 1.05277f $ **FLOATING
C1062 IOVDD.n363 VSS 0.70185f $ **FLOATING
C1063 IOVDD.n364 VSS 0.70185f $ **FLOATING
C1064 IOVDD.t13 VSS 1.05277f $ **FLOATING
C1065 IOVDD.n365 VSS 0.52639f $ **FLOATING
C1066 IOVDD.t31 VSS 0.87731f $ **FLOATING
C1067 IOVDD.t17 VSS 1.40369f $ **FLOATING
C1068 IOVDD.n366 VSS 0.70185f $ **FLOATING
C1069 IOVDD.t4 VSS 0.89279f $ **FLOATING
C1070 IOVDD.n367 VSS 0.70185f $ **FLOATING
C1071 IOVDD.n368 VSS 0.70185f $ **FLOATING
C1072 IOVDD.n369 VSS 0.70185f $ **FLOATING
C1073 IOVDD.t24 VSS 0.70185f $ **FLOATING
C1074 IOVDD.t0 VSS 0.70185f $ **FLOATING
C1075 IOVDD.n370 VSS 0.70185f $ **FLOATING
C1076 IOVDD.t22 VSS 0.70185f $ **FLOATING
C1077 IOVDD.n371 VSS 0.70185f $ **FLOATING
C1078 IOVDD.n372 VSS 0.70185f $ **FLOATING
C1079 IOVDD.n373 VSS 0.70185f $ **FLOATING
C1080 IOVDD.n374 VSS 0.06783f $ **FLOATING
C1081 IOVDD.n375 VSS 0.06783f $ **FLOATING
C1082 IOVDD.n376 VSS 0.06783f $ **FLOATING
C1083 IOVDD.n377 VSS 0.06882f $ **FLOATING
C1084 IOVDD.n378 VSS 0.06783f $ **FLOATING
C1085 IOVDD.n379 VSS 0.06783f $ **FLOATING
C1086 IOVDD.n380 VSS 0.06882f $ **FLOATING
C1087 IOVDD.n381 VSS 0.06783f $ **FLOATING
C1088 IOVDD.n382 VSS 0.06783f $ **FLOATING
C1089 IOVDD.n383 VSS 0.06783f $ **FLOATING
C1090 IOVDD.n384 VSS 0.06882f $ **FLOATING
C1091 IOVDD.n385 VSS 0.06783f $ **FLOATING
C1092 IOVDD.n386 VSS 0.06783f $ **FLOATING
C1093 IOVDD.n387 VSS 0.06882f $ **FLOATING
C1094 IOVDD.n388 VSS 0.06783f $ **FLOATING
C1095 IOVDD.n389 VSS 0.06783f $ **FLOATING
C1096 IOVDD.n390 VSS 0.06783f $ **FLOATING
C1097 IOVDD.n391 VSS 0.06882f $ **FLOATING
C1098 IOVDD.n392 VSS 0.06783f $ **FLOATING
C1099 IOVDD.n393 VSS 0.06783f $ **FLOATING
C1100 IOVDD.n394 VSS 0.06882f $ **FLOATING
C1101 IOVDD.n395 VSS 0.06783f $ **FLOATING
C1102 IOVDD.n396 VSS 0.06783f $ **FLOATING
C1103 IOVDD.n397 VSS 0.06783f $ **FLOATING
C1104 IOVDD.n398 VSS 0.06882f $ **FLOATING
C1105 IOVDD.n399 VSS 0.06783f $ **FLOATING
C1106 IOVDD.n400 VSS 0.06783f $ **FLOATING
C1107 IOVDD.n401 VSS 0.06882f $ **FLOATING
C1108 IOVDD.t52 VSS 0.09317f $ **FLOATING
C1109 IOVDD.t91 VSS 0.09317f $ **FLOATING
C1110 IOVDD.t90 VSS 0.09317f $ **FLOATING
C1111 IOVDD.n402 VSS 0.06685f $ **FLOATING
C1112 IOVDD.n403 VSS 0.06685f $ **FLOATING
C1113 IOVDD.n404 VSS 0.06685f $ **FLOATING
C1114 IOVDD.n405 VSS 0.06685f $ **FLOATING
C1115 IOVDD.n406 VSS 0.06685f $ **FLOATING
C1116 IOVDD.n407 VSS 0.06685f $ **FLOATING
C1117 IOVDD.n408 VSS 0.06685f $ **FLOATING
C1118 IOVDD.n409 VSS 0.06685f $ **FLOATING
C1119 IOVDD.n410 VSS 0.06685f $ **FLOATING
C1120 IOVDD.n411 VSS 0.06685f $ **FLOATING
C1121 IOVDD.n412 VSS 0.06685f $ **FLOATING
C1122 IOVDD.n413 VSS 0.06685f $ **FLOATING
C1123 IOVDD.n414 VSS 0.06685f $ **FLOATING
C1124 IOVDD.n415 VSS 0.6859f $ **FLOATING
C1125 IOVDD.n416 VSS 0.06685f $ **FLOATING
C1126 IOVDD.n417 VSS 0.06685f $ **FLOATING
C1127 IOVDD.n418 VSS 0.06685f $ **FLOATING
C1128 IOVDD.n419 VSS 0.06685f $ **FLOATING
C1129 IOVDD.n420 VSS 0.06685f $ **FLOATING
C1130 IOVDD.n421 VSS 0.06685f $ **FLOATING
C1131 IOVDD.n422 VSS 0.06685f $ **FLOATING
C1132 IOVDD.n423 VSS 0.06685f $ **FLOATING
C1133 IOVDD.n424 VSS 0.06685f $ **FLOATING
C1134 IOVDD.n425 VSS 0.06685f $ **FLOATING
C1135 IOVDD.n426 VSS 0.06685f $ **FLOATING
C1136 IOVDD.n427 VSS 0.06685f $ **FLOATING
C1137 IOVDD.n428 VSS 0.06685f $ **FLOATING
C1138 IOVDD.n429 VSS 0.06685f $ **FLOATING
C1139 IOVDD.t51 VSS 0.09317f $ **FLOATING
C1140 IOVDD.n430 VSS 0.12755f $ **FLOATING
C1141 IOVDD.n431 VSS 0.06332f $ **FLOATING
C1142 IOVDD.n432 VSS 0.06364f $ **FLOATING
C1143 IOVDD.t49 VSS 2.74963f $ **FLOATING
C1144 IOVDD.n433 VSS 0.04747f $ **FLOATING
C1145 IOVDD.n434 VSS 0.15523f $ **FLOATING
C1146 IOVDD.t89 VSS 2.86087f $ **FLOATING
C1147 IOVDD.n436 VSS 0.15854f $ **FLOATING
C1148 IOVDD.n437 VSS 0.06788f $ **FLOATING
C1149 IOVDD.n438 VSS 0.06783f $ **FLOATING
C1150 IOVDD.n439 VSS 0.06783f $ **FLOATING
C1151 IOVDD.n440 VSS 0.06783f $ **FLOATING
C1152 IOVDD.n441 VSS 0.06882f $ **FLOATING
C1153 IOVDD.n442 VSS 0.06783f $ **FLOATING
C1154 IOVDD.n443 VSS 0.06783f $ **FLOATING
C1155 IOVDD.n444 VSS 0.06882f $ **FLOATING
C1156 IOVDD.n445 VSS 0.06783f $ **FLOATING
C1157 IOVDD.n446 VSS 0.06783f $ **FLOATING
C1158 IOVDD.n447 VSS 0.06783f $ **FLOATING
C1159 IOVDD.n448 VSS 0.06882f $ **FLOATING
C1160 IOVDD.n449 VSS 0.06783f $ **FLOATING
C1161 IOVDD.n450 VSS 0.06783f $ **FLOATING
C1162 IOVDD.n451 VSS 0.06882f $ **FLOATING
C1163 IOVDD.n452 VSS 0.06783f $ **FLOATING
C1164 IOVDD.n453 VSS 0.06783f $ **FLOATING
C1165 IOVDD.n454 VSS 0.06783f $ **FLOATING
C1166 IOVDD.n455 VSS 0.06882f $ **FLOATING
C1167 IOVDD.n456 VSS 0.06783f $ **FLOATING
C1168 IOVDD.n457 VSS 0.06783f $ **FLOATING
C1169 IOVDD.n458 VSS 0.06882f $ **FLOATING
C1170 IOVDD.n459 VSS 0.06783f $ **FLOATING
C1171 IOVDD.n460 VSS 0.06783f $ **FLOATING
C1172 IOVDD.n461 VSS 0.06783f $ **FLOATING
C1173 IOVDD.n462 VSS 0.06882f $ **FLOATING
C1174 IOVDD.n463 VSS 0.06783f $ **FLOATING
C1175 IOVDD.n464 VSS 0.06783f $ **FLOATING
C1176 IOVDD.n465 VSS 0.06882f $ **FLOATING
C1177 IOVDD.t74 VSS 0.09317f $ **FLOATING
C1178 IOVDD.t118 VSS 0.09317f $ **FLOATING
C1179 IOVDD.t117 VSS 0.09317f $ **FLOATING
C1180 IOVDD.n466 VSS 0.06685f $ **FLOATING
C1181 IOVDD.n467 VSS 0.06685f $ **FLOATING
C1182 IOVDD.n468 VSS 0.06685f $ **FLOATING
C1183 IOVDD.n469 VSS 0.06685f $ **FLOATING
C1184 IOVDD.n470 VSS 0.06685f $ **FLOATING
C1185 IOVDD.n471 VSS 0.06685f $ **FLOATING
C1186 IOVDD.n472 VSS 0.06685f $ **FLOATING
C1187 IOVDD.n473 VSS 0.06685f $ **FLOATING
C1188 IOVDD.n474 VSS 0.06685f $ **FLOATING
C1189 IOVDD.n475 VSS 0.06685f $ **FLOATING
C1190 IOVDD.n476 VSS 0.06685f $ **FLOATING
C1191 IOVDD.n477 VSS 0.06685f $ **FLOATING
C1192 IOVDD.n478 VSS 0.06685f $ **FLOATING
C1193 IOVDD.n479 VSS 0.12755f $ **FLOATING
C1194 IOVDD.n480 VSS 0.06685f $ **FLOATING
C1195 IOVDD.n481 VSS 0.06685f $ **FLOATING
C1196 IOVDD.n482 VSS 0.06685f $ **FLOATING
C1197 IOVDD.n483 VSS 0.06685f $ **FLOATING
C1198 IOVDD.n484 VSS 0.06685f $ **FLOATING
C1199 IOVDD.n485 VSS 0.06685f $ **FLOATING
C1200 IOVDD.n486 VSS 0.06685f $ **FLOATING
C1201 IOVDD.n487 VSS 0.06685f $ **FLOATING
C1202 IOVDD.n488 VSS 0.06685f $ **FLOATING
C1203 IOVDD.n489 VSS 0.06685f $ **FLOATING
C1204 IOVDD.n490 VSS 0.06685f $ **FLOATING
C1205 IOVDD.n491 VSS 0.06685f $ **FLOATING
C1206 IOVDD.n492 VSS 0.06685f $ **FLOATING
C1207 IOVDD.n493 VSS 0.06685f $ **FLOATING
C1208 IOVDD.t73 VSS 0.09317f $ **FLOATING
C1209 IOVDD.n494 VSS 0.2877f $ **FLOATING
C1210 IOVDD.n495 VSS 0.13505f $ **FLOATING
C1211 IOVDD.n497 VSS 0.03872f $ **FLOATING
C1212 IOVDD.n509 VSS 0.04884f $ **FLOATING
C1213 IOVDD.n510 VSS 0.06016f $ **FLOATING
C1214 IOVDD.n511 VSS 0.0251f $ **FLOATING
C1215 IOVDD.n512 VSS 0.69539f $ **FLOATING
C1216 IOVDD.n514 VSS 0.02141f $ **FLOATING
C1217 IOVDD.t92 VSS 0.56819f $ **FLOATING
C1218 IOVDD.n516 VSS 0.0125f $ **FLOATING
C1219 IOVDD.n517 VSS 0.02141f $ **FLOATING
C1220 IOVDD.n518 VSS 0.04042f $ **FLOATING
C1221 IOVDD.t114 VSS 0.60294f $ **FLOATING
C1222 IOVDD.n535 VSS 0.09043f $ **FLOATING
C1223 IOVDD.t23 VSS 0.1359f $ **FLOATING
C1224 IOVDD.t5 VSS 0.1359f $ **FLOATING
C1225 IOVDD.n536 VSS 0.08345f $ **FLOATING
C1226 IOVDD.n537 VSS 0.10377f $ **FLOATING
C1227 IOVDD.t218 VSS 2.57353f $ **FLOATING
C1228 IOVDD.t224 VSS 5.75107f $ **FLOATING
C1229 IOVDD.t223 VSS 5.9437f $ **FLOATING
C1230 IOVDD.t221 VSS 5.66188f $ **FLOATING
C1231 IOVDD.n538 VSS 0.07609f $ **FLOATING
C1232 IOVDD.n539 VSS 0.02608f $ **FLOATING
C1233 IOVDD.n540 VSS 0.02986f $ **FLOATING
C1234 IOVDD.t155 VSS 0.56235f $ **FLOATING
C1235 IOVDD.n543 VSS 0.01478f $ **FLOATING
C1236 IOVDD.n544 VSS 0.0578f $ **FLOATING
C1237 IOVDD.t129 VSS 0.5736f $ **FLOATING
C1238 IOVDD.n545 VSS 0.0204f $ **FLOATING
C1239 IOVDD.n546 VSS 0.05668f $ **FLOATING
C1240 IOVDD.n547 VSS 0.01689f $ **FLOATING
C1241 IOVDD.n548 VSS 0.0303f $ **FLOATING
C1242 IOVDD.n549 VSS 0.0303f $ **FLOATING
C1243 IOVDD.n550 VSS 0.0303f $ **FLOATING
C1244 IOVDD.n551 VSS 0.03074f $ **FLOATING
C1245 IOVDD.n552 VSS 0.0303f $ **FLOATING
C1246 IOVDD.n553 VSS 0.0303f $ **FLOATING
C1247 IOVDD.n554 VSS 0.03074f $ **FLOATING
C1248 IOVDD.n555 VSS 0.0303f $ **FLOATING
C1249 IOVDD.n556 VSS 0.0303f $ **FLOATING
C1250 IOVDD.n557 VSS 0.0303f $ **FLOATING
C1251 IOVDD.n558 VSS 0.03074f $ **FLOATING
C1252 IOVDD.n559 VSS 0.0303f $ **FLOATING
C1253 IOVDD.n560 VSS 0.0303f $ **FLOATING
C1254 IOVDD.n561 VSS 0.0303f $ **FLOATING
C1255 IOVDD.n562 VSS 0.0303f $ **FLOATING
C1256 IOVDD.n563 VSS 0.0303f $ **FLOATING
C1257 IOVDD.n564 VSS 0.03074f $ **FLOATING
C1258 IOVDD.n565 VSS 0.0303f $ **FLOATING
C1259 IOVDD.n566 VSS 0.0303f $ **FLOATING
C1260 IOVDD.n567 VSS 0.03074f $ **FLOATING
C1261 IOVDD.n568 VSS 0.0303f $ **FLOATING
C1262 IOVDD.n569 VSS 0.0303f $ **FLOATING
C1263 IOVDD.n570 VSS 0.0303f $ **FLOATING
C1264 IOVDD.n571 VSS 0.03074f $ **FLOATING
C1265 IOVDD.n572 VSS 0.0303f $ **FLOATING
C1266 IOVDD.n573 VSS 0.0303f $ **FLOATING
C1267 IOVDD.n574 VSS 0.03074f $ **FLOATING
C1268 IOVDD.t14 VSS 0.20826f $ **FLOATING
C1269 IOVDD.n575 VSS 0.02986f $ **FLOATING
C1270 IOVDD.n576 VSS 0.02986f $ **FLOATING
C1271 IOVDD.n577 VSS 0.02986f $ **FLOATING
C1272 IOVDD.n578 VSS 0.02986f $ **FLOATING
C1273 IOVDD.n579 VSS 0.02986f $ **FLOATING
C1274 IOVDD.n580 VSS 0.02986f $ **FLOATING
C1275 IOVDD.n581 VSS 0.04391f $ **FLOATING
C1276 IOVDD.n582 VSS 0.04304f $ **FLOATING
C1277 IOVDD.n584 VSS 0.02986f $ **FLOATING
C1278 IOVDD.n585 VSS 0.02986f $ **FLOATING
C1279 IOVDD.n586 VSS 0.02986f $ **FLOATING
C1280 IOVDD.n587 VSS 0.02986f $ **FLOATING
C1281 IOVDD.n588 VSS 0.02986f $ **FLOATING
C1282 IOVDD.n589 VSS 0.02986f $ **FLOATING
C1283 IOVDD.n590 VSS 0.05686f $ **FLOATING
C1284 IOVDD.n591 VSS 0.02986f $ **FLOATING
C1285 IOVDD.n592 VSS 0.02986f $ **FLOATING
C1286 IOVDD.n593 VSS 0.02986f $ **FLOATING
C1287 IOVDD.n594 VSS 0.02986f $ **FLOATING
C1288 IOVDD.n595 VSS 0.02986f $ **FLOATING
C1289 IOVDD.n596 VSS 0.02986f $ **FLOATING
C1290 IOVDD.n597 VSS 0.02986f $ **FLOATING
C1291 IOVDD.n598 VSS 0.02986f $ **FLOATING
C1292 IOVDD.n599 VSS 0.02986f $ **FLOATING
C1293 IOVDD.n600 VSS 0.02986f $ **FLOATING
C1294 IOVDD.n601 VSS 0.02986f $ **FLOATING
C1295 IOVDD.n602 VSS 0.02986f $ **FLOATING
C1296 IOVDD.n603 VSS 0.02986f $ **FLOATING
C1297 IOVDD.t157 VSS 0.09317f $ **FLOATING
C1298 IOVDD.n604 VSS 0.02986f $ **FLOATING
C1299 IOVDD.n605 VSS 0.01186f $ **FLOATING
C1300 IOVDD.n616 VSS 0.04611f $ **FLOATING
C1301 IOVDD.n617 VSS 0.04611f $ **FLOATING
C1302 IOVDD.n618 VSS 0.04611f $ **FLOATING
C1303 IOVDD.n619 VSS 0.04678f $ **FLOATING
C1304 IOVDD.n620 VSS 0.04611f $ **FLOATING
C1305 IOVDD.n621 VSS 0.04611f $ **FLOATING
C1306 IOVDD.n622 VSS 0.04678f $ **FLOATING
C1307 IOVDD.n623 VSS 0.04611f $ **FLOATING
C1308 IOVDD.n624 VSS 0.04611f $ **FLOATING
C1309 IOVDD.n625 VSS 0.04611f $ **FLOATING
C1310 IOVDD.n626 VSS 0.04678f $ **FLOATING
C1311 IOVDD.n627 VSS 0.04611f $ **FLOATING
C1312 IOVDD.n628 VSS 0.04611f $ **FLOATING
C1313 IOVDD.n629 VSS 0.04678f $ **FLOATING
C1314 IOVDD.n630 VSS 0.04611f $ **FLOATING
C1315 IOVDD.n631 VSS 0.04611f $ **FLOATING
C1316 IOVDD.n632 VSS 0.04611f $ **FLOATING
C1317 IOVDD.n633 VSS 0.04678f $ **FLOATING
C1318 IOVDD.n634 VSS 0.04611f $ **FLOATING
C1319 IOVDD.n635 VSS 0.04611f $ **FLOATING
C1320 IOVDD.n636 VSS 0.04678f $ **FLOATING
C1321 IOVDD.n637 VSS 0.04611f $ **FLOATING
C1322 IOVDD.n638 VSS 0.04611f $ **FLOATING
C1323 IOVDD.n639 VSS 0.04611f $ **FLOATING
C1324 IOVDD.n640 VSS 0.04678f $ **FLOATING
C1325 IOVDD.n641 VSS 0.04611f $ **FLOATING
C1326 IOVDD.n642 VSS 0.04611f $ **FLOATING
C1327 IOVDD.n643 VSS 0.04678f $ **FLOATING
C1328 IOVDD.t67 VSS 0.09317f $ **FLOATING
C1329 IOVDD.t159 VSS 0.09317f $ **FLOATING
C1330 IOVDD.n644 VSS 0.04544f $ **FLOATING
C1331 IOVDD.n645 VSS 0.04544f $ **FLOATING
C1332 IOVDD.n646 VSS 0.04544f $ **FLOATING
C1333 IOVDD.n647 VSS 0.04544f $ **FLOATING
C1334 IOVDD.n648 VSS 0.04544f $ **FLOATING
C1335 IOVDD.n649 VSS 0.04544f $ **FLOATING
C1336 IOVDD.n650 VSS 0.04544f $ **FLOATING
C1337 IOVDD.n651 VSS 0.04544f $ **FLOATING
C1338 IOVDD.n652 VSS 0.04544f $ **FLOATING
C1339 IOVDD.n653 VSS 0.04544f $ **FLOATING
C1340 IOVDD.n654 VSS 0.04544f $ **FLOATING
C1341 IOVDD.n655 VSS 0.04544f $ **FLOATING
C1342 IOVDD.n656 VSS 0.04544f $ **FLOATING
C1343 IOVDD.n657 VSS 0.04544f $ **FLOATING
C1344 IOVDD.n658 VSS 0.04544f $ **FLOATING
C1345 IOVDD.n659 VSS 0.04544f $ **FLOATING
C1346 IOVDD.n660 VSS 0.04544f $ **FLOATING
C1347 IOVDD.n661 VSS 0.04544f $ **FLOATING
C1348 IOVDD.n662 VSS 0.04544f $ **FLOATING
C1349 IOVDD.n663 VSS 0.04544f $ **FLOATING
C1350 IOVDD.n664 VSS 0.04544f $ **FLOATING
C1351 IOVDD.n665 VSS 0.04544f $ **FLOATING
C1352 IOVDD.n666 VSS 0.04544f $ **FLOATING
C1353 IOVDD.n667 VSS 0.04544f $ **FLOATING
C1354 IOVDD.n668 VSS 0.04544f $ **FLOATING
C1355 IOVDD.n669 VSS 0.04544f $ **FLOATING
C1356 IOVDD.n670 VSS 0.44933f $ **FLOATING
C1357 IOVDD.n671 VSS 0.04544f $ **FLOATING
C1358 IOVDD.t160 VSS 0.09317f $ **FLOATING
C1359 IOVDD.n672 VSS 0.08554f $ **FLOATING
C1360 IOVDD.n673 VSS 0.04567f $ **FLOATING
C1361 IOVDD.n674 VSS 0.06685f $ **FLOATING
C1362 IOVDD.t85 VSS 0.09317f $ **FLOATING
C1363 IOVDD.n675 VSS 0.55056f $ **FLOATING
C1364 IOVDD.n676 VSS 0.45759f $ **FLOATING
C1365 IOVDD.t66 VSS 0.09317f $ **FLOATING
C1366 IOVDD.n677 VSS 0.9787f $ **FLOATING
C1367 IOVDD.n678 VSS 0.44575f $ **FLOATING
C1368 IOVDD.n679 VSS 0.06299f $ **FLOATING
C1369 IOVDD.t65 VSS 2.72677f $ **FLOATING
C1370 IOVDD.n681 VSS 0.02311f $ **FLOATING
C1371 IOVDD.n683 VSS 0.04791f $ **FLOATING
C1372 IOVDD.n684 VSS 0.06341f $ **FLOATING
C1373 IOVDD.t32 VSS 2.74962f $ **FLOATING
C1374 IOVDD.n685 VSS 0.06268f $ **FLOATING
C1375 IOVDD.n686 VSS 0.04768f $ **FLOATING
C1376 IOVDD.n687 VSS 0.10223f $ **FLOATING
C1377 IOVDD.n688 VSS 0.04886f $ **FLOATING
C1378 IOVDD.n689 VSS 0.04611f $ **FLOATING
C1379 IOVDD.n690 VSS 0.04611f $ **FLOATING
C1380 IOVDD.n691 VSS 0.04611f $ **FLOATING
C1381 IOVDD.n692 VSS 0.04678f $ **FLOATING
C1382 IOVDD.n693 VSS 0.04611f $ **FLOATING
C1383 IOVDD.n694 VSS 0.04611f $ **FLOATING
C1384 IOVDD.n695 VSS 0.04678f $ **FLOATING
C1385 IOVDD.n696 VSS 0.04611f $ **FLOATING
C1386 IOVDD.n697 VSS 0.04611f $ **FLOATING
C1387 IOVDD.n698 VSS 0.04611f $ **FLOATING
C1388 IOVDD.n699 VSS 0.04678f $ **FLOATING
C1389 IOVDD.n700 VSS 0.04611f $ **FLOATING
C1390 IOVDD.n701 VSS 0.04611f $ **FLOATING
C1391 IOVDD.n702 VSS 0.04678f $ **FLOATING
C1392 IOVDD.n703 VSS 0.04611f $ **FLOATING
C1393 IOVDD.n704 VSS 0.04611f $ **FLOATING
C1394 IOVDD.n705 VSS 0.04611f $ **FLOATING
C1395 IOVDD.n706 VSS 0.04678f $ **FLOATING
C1396 IOVDD.n707 VSS 0.04611f $ **FLOATING
C1397 IOVDD.n708 VSS 0.04611f $ **FLOATING
C1398 IOVDD.n709 VSS 0.04678f $ **FLOATING
C1399 IOVDD.n710 VSS 0.04611f $ **FLOATING
C1400 IOVDD.n711 VSS 0.04611f $ **FLOATING
C1401 IOVDD.n712 VSS 0.04611f $ **FLOATING
C1402 IOVDD.n713 VSS 0.04678f $ **FLOATING
C1403 IOVDD.n714 VSS 0.04611f $ **FLOATING
C1404 IOVDD.n715 VSS 0.04611f $ **FLOATING
C1405 IOVDD.n716 VSS 0.04678f $ **FLOATING
C1406 IOVDD.t86 VSS 0.09317f $ **FLOATING
C1407 IOVDD.t34 VSS 0.09317f $ **FLOATING
C1408 IOVDD.n717 VSS 0.04544f $ **FLOATING
C1409 IOVDD.n718 VSS 0.04544f $ **FLOATING
C1410 IOVDD.n719 VSS 0.04544f $ **FLOATING
C1411 IOVDD.n720 VSS 0.04544f $ **FLOATING
C1412 IOVDD.n721 VSS 0.04544f $ **FLOATING
C1413 IOVDD.n722 VSS 0.04544f $ **FLOATING
C1414 IOVDD.n723 VSS 0.04544f $ **FLOATING
C1415 IOVDD.n724 VSS 0.04544f $ **FLOATING
C1416 IOVDD.n725 VSS 0.04544f $ **FLOATING
C1417 IOVDD.n726 VSS 0.04544f $ **FLOATING
C1418 IOVDD.n727 VSS 0.04544f $ **FLOATING
C1419 IOVDD.n728 VSS 0.04544f $ **FLOATING
C1420 IOVDD.n729 VSS 0.04544f $ **FLOATING
C1421 IOVDD.n730 VSS 0.04544f $ **FLOATING
C1422 IOVDD.n731 VSS 0.04544f $ **FLOATING
C1423 IOVDD.n732 VSS 0.04544f $ **FLOATING
C1424 IOVDD.n733 VSS 0.04544f $ **FLOATING
C1425 IOVDD.n734 VSS 0.04544f $ **FLOATING
C1426 IOVDD.n735 VSS 0.04544f $ **FLOATING
C1427 IOVDD.n736 VSS 0.04544f $ **FLOATING
C1428 IOVDD.n737 VSS 0.04544f $ **FLOATING
C1429 IOVDD.n738 VSS 0.04544f $ **FLOATING
C1430 IOVDD.n739 VSS 0.04544f $ **FLOATING
C1431 IOVDD.n740 VSS 0.04544f $ **FLOATING
C1432 IOVDD.n741 VSS 0.04544f $ **FLOATING
C1433 IOVDD.n742 VSS 0.04544f $ **FLOATING
C1434 IOVDD.n743 VSS 0.08554f $ **FLOATING
C1435 IOVDD.n744 VSS 0.04544f $ **FLOATING
C1436 IOVDD.t35 VSS 0.09317f $ **FLOATING
C1437 IOVDD.n745 VSS 0.21921f $ **FLOATING
C1438 IOVDD.n746 VSS 0.05329f $ **FLOATING
C1439 IOVDD.n748 VSS 0.01202f $ **FLOATING
C1440 IOVDD.n749 VSS 0.01202f $ **FLOATING
C1441 IOVDD.n751 VSS 0.01202f $ **FLOATING
C1442 IOVDD.n753 VSS 0.01202f $ **FLOATING
C1443 IOVDD.n755 VSS 0.01202f $ **FLOATING
C1444 IOVDD.n757 VSS 0.01202f $ **FLOATING
C1445 IOVDD.n759 VSS 0.01202f $ **FLOATING
C1446 IOVDD.n761 VSS 0.05318f $ **FLOATING
C1447 IOVDD.n762 VSS 0.04523f $ **FLOATING
C1448 IOVDD.n764 VSS 0.53746f $ **FLOATING
C1449 IOVDD.n765 VSS 0.05513f $ **FLOATING
C1450 IOVDD.n766 VSS 0.1541f $ **FLOATING
C1451 IOVDD.n768 VSS 0.01642f $ **FLOATING
C1452 IOVDD.n769 VSS 0.07965f $ **FLOATING
C1453 IOVDD.n770 VSS 0.05697f $ **FLOATING
C1454 IOVDD.n771 VSS 0.07525f $ **FLOATING
C1455 IOVDD.n773 VSS 0.1218f $ **FLOATING
C1456 IOVDD.n774 VSS 0.02172f $ **FLOATING
C1457 IOVDD.n776 VSS 0.02172f $ **FLOATING
C1458 IOVDD.n777 VSS 0.02928f $ **FLOATING
C1459 IOVDD.n778 VSS 0.22549f $ **FLOATING
C1460 IOVDD.n779 VSS 0.10635f $ **FLOATING
C1461 IOVDD.n780 VSS 0.01752f $ **FLOATING
C1462 IOVDD.n781 VSS 0.02103f $ **FLOATING
C1463 IOVDD.n783 VSS 0.23759f $ **FLOATING
C1464 IOVDD.n788 VSS 0.26182f $ **FLOATING
C1465 IOVDD.n791 VSS 0.04194f $ **FLOATING
C1466 IOVDD.n792 VSS 0.5705f $ **FLOATING
C1467 IOVDD.t50 VSS 12.4582f $ **FLOATING
C1468 IOVDD.n797 VSS 0.02172f $ **FLOATING
C1469 IOVDD.n798 VSS 0.02141f $ **FLOATING
C1470 IOVDD.t93 VSS 0.15235f $ **FLOATING
C1471 IOVDD.n799 VSS 0.02141f $ **FLOATING
C1472 IOVDD.n800 VSS 0.02204f $ **FLOATING
C1473 IOVDD.t219 VSS 2.57353f $ **FLOATING
C1474 IOVDD.t217 VSS 5.75107f $ **FLOATING
C1475 IOVDD.t222 VSS 5.9437f $ **FLOATING
C1476 IOVDD.t220 VSS 5.70694f $ **FLOATING
C1477 IOVDD.n803 VSS 0.06087f $ **FLOATING
C1478 IOVDD.n804 VSS 0.08338f $ **FLOATING
C1479 IOVDD.n805 VSS 0.07209f $ **FLOATING
C1480 IOVDD.n806 VSS 0.04998f $ **FLOATING
C1481 IOVDD.n807 VSS 0.03499f $ **FLOATING
C1482 IOVDD.n808 VSS 0.03499f $ **FLOATING
C1483 IOVDD.n809 VSS 0.03946f $ **FLOATING
C1484 IOVDD.n810 VSS 0.03499f $ **FLOATING
C1485 IOVDD.n811 VSS 0.03499f $ **FLOATING
C1486 IOVDD.n812 VSS 0.04998f $ **FLOATING
C1487 IOVDD.n813 VSS 0.03499f $ **FLOATING
C1488 IOVDD.n814 VSS 0.03499f $ **FLOATING
C1489 IOVDD.n815 VSS 0.03499f $ **FLOATING
C1490 IOVDD.n816 VSS 0.01066f $ **FLOATING
C1491 IOVDD.n817 VSS 0.14886f $ **FLOATING
C1492 IOVDD.n818 VSS 0.35936f $ **FLOATING
C1493 IOVDD.t57 VSS 0.71871f $ **FLOATING
C1494 IOVDD.t43 VSS 2.69518f $ **FLOATING
C1495 IOVDD.n820 VSS 0.01283f $ **FLOATING
C1496 IOVDD.t126 VSS 3.52487f $ **FLOATING
C1497 IOVDD.n822 VSS 0.03248f $ **FLOATING
C1498 IOVDD.n823 VSS 0.02343f $ **FLOATING
C1499 IOVDD.n824 VSS 0.03667f $ **FLOATING
C1500 IOVDD.n825 VSS 0.06411f $ **FLOATING
C1501 IOVDD.n826 VSS 0.03411f $ **FLOATING
C1502 IOVDD.n827 VSS 0.02343f $ **FLOATING
C1503 IOVDD.n828 VSS 0.02701f $ **FLOATING
C1504 IOVDD.n829 VSS 0.0287f $ **FLOATING
C1505 IOVDD.n830 VSS 0.04253f $ **FLOATING
C1506 IOVDD.n831 VSS 0.04178f $ **FLOATING
C1507 IOVDD.n832 VSS 0.03714f $ **FLOATING
C1508 IOVDD.t75 VSS 0.176f $ **FLOATING
C1509 IOVDD.n833 VSS 0.04253f $ **FLOATING
C1510 IOVDD.n834 VSS 0.02868f $ **FLOATING
C1511 IOVDD.n835 VSS 0.04177f $ **FLOATING
C1512 IOVDD.n836 VSS 0.03501f $ **FLOATING
C1513 IOVDD.n837 VSS 0.12674f $ **FLOATING
C1514 IOVDD.n838 VSS 0.0435f $ **FLOATING
C1515 IOVDD.n839 VSS 0.89535f $ **FLOATING
C1516 IOVDD.n843 VSS 0.01691f $ **FLOATING
C1517 IOVDD.n844 VSS 0.03802f $ **FLOATING
C1518 IOVDD.n846 VSS 0.01193f $ **FLOATING
C1519 IOVDD.n847 VSS 0.01193f $ **FLOATING
C1520 IOVDD.n848 VSS 0.01193f $ **FLOATING
C1521 IOVDD.t180 VSS 0.01863f $ **FLOATING
C1522 IOVDD.t179 VSS 0.01901f $ **FLOATING
C1523 IOVDD.t181 VSS 0.019f $ **FLOATING
C1524 IOVDD.n850 VSS 0.07726f $ **FLOATING
C1525 IOVDD.n851 VSS 0.03599f $ **FLOATING
C1526 IOVDD.t182 VSS 0.01863f $ **FLOATING
C1527 IOVDD.n852 VSS 0.02636f $ **FLOATING
C1528 IOVDD.n853 VSS 0.03234f $ **FLOATING
C1529 IOVDD.n854 VSS 0.02581f $ **FLOATING
C1530 IOVDD.n855 VSS 0.01205f $ **FLOATING
C1531 IOVDD.n856 VSS 0.02581f $ **FLOATING
C1532 IOVDD.n857 VSS 0.02581f $ **FLOATING
C1533 IOVDD.n858 VSS 0.02581f $ **FLOATING
C1534 IOVDD.n859 VSS 0.02581f $ **FLOATING
C1535 IOVDD.n860 VSS 0.02581f $ **FLOATING
C1536 IOVDD.t127 VSS 0.01863f $ **FLOATING
C1537 IOVDD.t58 VSS 0.01863f $ **FLOATING
C1538 IOVDD.t128 VSS 0.01863f $ **FLOATING
C1539 IOVDD.n861 VSS 0.02581f $ **FLOATING
C1540 IOVDD.n862 VSS 0.02581f $ **FLOATING
C1541 IOVDD.n863 VSS 0.02581f $ **FLOATING
C1542 IOVDD.n864 VSS 0.04903f $ **FLOATING
C1543 IOVDD.n865 VSS 0.02581f $ **FLOATING
C1544 IOVDD.t59 VSS 0.01863f $ **FLOATING
C1545 IOVDD.n866 VSS 0.08196f $ **FLOATING
C1546 IOVDD.n867 VSS 0.08097f $ **FLOATING
C1547 IOVDD.n868 VSS 0.02581f $ **FLOATING
C1548 IOVDD.n869 VSS 0.02581f $ **FLOATING
C1549 IOVDD.n870 VSS 0.02581f $ **FLOATING
C1550 IOVDD.n871 VSS 0.02581f $ **FLOATING
C1551 IOVDD.n872 VSS 0.02581f $ **FLOATING
C1552 IOVDD.t163 VSS 0.01863f $ **FLOATING
C1553 IOVDD.t102 VSS 0.01863f $ **FLOATING
C1554 IOVDD.t101 VSS 0.01863f $ **FLOATING
C1555 IOVDD.n873 VSS 0.02581f $ **FLOATING
C1556 IOVDD.n874 VSS 0.02581f $ **FLOATING
C1557 IOVDD.n875 VSS 0.03644f $ **FLOATING
C1558 IOVDD.n876 VSS 0.08301f $ **FLOATING
C1559 IOVDD.n877 VSS 0.02581f $ **FLOATING
C1560 IOVDD.t162 VSS 0.01863f $ **FLOATING
C1561 IOVDD.n878 VSS 0.04555f $ **FLOATING
C1562 IOVDD.n879 VSS 0.02743f $ **FLOATING
C1563 IOVDD.n880 VSS 0.02581f $ **FLOATING
C1564 IOVDD.t100 VSS 0.13373f $ **FLOATING
C1565 IOVDD.n881 VSS 0.05037f $ **FLOATING
C1566 IOVDD.t161 VSS 0.13373f $ **FLOATING
C1567 IOVDD.n882 VSS 0.02581f $ **FLOATING
C1568 IOVDD.n883 VSS 0.04516f $ **FLOATING
C1569 IOVDD.n884 VSS 0.02581f $ **FLOATING
C1570 IOVDD.n885 VSS 0.02581f $ **FLOATING
C1571 IOVDD.n886 VSS 0.02581f $ **FLOATING
C1572 IOVDD.n887 VSS 0.02581f $ **FLOATING
C1573 IOVDD.n888 VSS 0.12419f $ **FLOATING
C1574 IOVDD.t166 VSS 0.01863f $ **FLOATING
C1575 IOVDD.t105 VSS 0.01863f $ **FLOATING
C1576 IOVDD.t104 VSS 0.01863f $ **FLOATING
C1577 IOVDD.n889 VSS 0.02581f $ **FLOATING
C1578 IOVDD.n890 VSS 0.02581f $ **FLOATING
C1579 IOVDD.n891 VSS 0.02581f $ **FLOATING
C1580 IOVDD.n892 VSS 0.02581f $ **FLOATING
C1581 IOVDD.t165 VSS 0.01863f $ **FLOATING
C1582 IOVDD.n893 VSS 0.02581f $ **FLOATING
C1583 IOVDD.n894 VSS 0.02581f $ **FLOATING
C1584 IOVDD.t62 VSS 0.37257f $ **FLOATING
C1585 IOVDD.n901 VSS 0.18036f $ **FLOATING
C1586 IOVDD.n904 VSS 0.07987f $ **FLOATING
C1587 IOVDD.n905 VSS 0.02581f $ **FLOATING
C1588 IOVDD.t141 VSS 0.06533f $ **FLOATING
C1589 IOVDD.n906 VSS 0.04798f $ **FLOATING
C1590 IOVDD.t68 VSS 0.06533f $ **FLOATING
C1591 IOVDD.n907 VSS 0.04975f $ **FLOATING
C1592 IOVDD.n908 VSS 0.01205f $ **FLOATING
C1593 IOVDD.n909 VSS 0.02581f $ **FLOATING
C1594 IOVDD.n910 VSS 0.02581f $ **FLOATING
C1595 IOVDD.n911 VSS 0.02581f $ **FLOATING
C1596 IOVDD.n912 VSS 0.02581f $ **FLOATING
C1597 IOVDD.n913 VSS 0.02581f $ **FLOATING
C1598 IOVDD.t71 VSS 0.01863f $ **FLOATING
C1599 IOVDD.t143 VSS 0.01863f $ **FLOATING
C1600 IOVDD.t142 VSS 0.01863f $ **FLOATING
C1601 IOVDD.n914 VSS 0.02581f $ **FLOATING
C1602 IOVDD.n915 VSS 0.02581f $ **FLOATING
C1603 IOVDD.n916 VSS 0.04903f $ **FLOATING
C1604 IOVDD.n917 VSS 0.02581f $ **FLOATING
C1605 IOVDD.n918 VSS 0.02581f $ **FLOATING
C1606 IOVDD.t70 VSS 0.01863f $ **FLOATING
C1607 IOVDD.n919 VSS 0.08091f $ **FLOATING
C1608 IOVDD.n920 VSS 0.0836f $ **FLOATING
C1609 IOVDD.n921 VSS 0.02581f $ **FLOATING
C1610 IOVDD.n922 VSS 0.02581f $ **FLOATING
C1611 IOVDD.n923 VSS 0.02581f $ **FLOATING
C1612 IOVDD.n924 VSS 0.02581f $ **FLOATING
C1613 IOVDD.n925 VSS 0.02581f $ **FLOATING
C1614 IOVDD.t110 VSS 0.01863f $ **FLOATING
C1615 IOVDD.t45 VSS 0.01863f $ **FLOATING
C1616 IOVDD.t44 VSS 0.01863f $ **FLOATING
C1617 IOVDD.n926 VSS 0.02581f $ **FLOATING
C1618 IOVDD.n927 VSS 0.02581f $ **FLOATING
C1619 IOVDD.n928 VSS 0.08143f $ **FLOATING
C1620 IOVDD.n929 VSS 0.03644f $ **FLOATING
C1621 IOVDD.n930 VSS 0.02581f $ **FLOATING
C1622 IOVDD.t109 VSS 0.01863f $ **FLOATING
C1623 IOVDD.n931 VSS 0.04555f $ **FLOATING
C1624 IOVDD.n932 VSS 0.02743f $ **FLOATING
C1625 IOVDD.n933 VSS 0.02581f $ **FLOATING
C1626 IOVDD.t42 VSS 0.13373f $ **FLOATING
C1627 IOVDD.n934 VSS 0.05037f $ **FLOATING
C1628 IOVDD.t108 VSS 0.13373f $ **FLOATING
C1629 IOVDD.n935 VSS 0.02581f $ **FLOATING
C1630 IOVDD.n936 VSS 0.04516f $ **FLOATING
C1631 IOVDD.n937 VSS 0.02581f $ **FLOATING
C1632 IOVDD.n938 VSS 0.02581f $ **FLOATING
C1633 IOVDD.n939 VSS 0.02581f $ **FLOATING
C1634 IOVDD.n940 VSS 0.02581f $ **FLOATING
C1635 IOVDD.n941 VSS 0.02581f $ **FLOATING
C1636 IOVDD.t113 VSS 0.01863f $ **FLOATING
C1637 IOVDD.t48 VSS 0.01863f $ **FLOATING
C1638 IOVDD.t47 VSS 0.01863f $ **FLOATING
C1639 IOVDD.n942 VSS 0.02581f $ **FLOATING
C1640 IOVDD.n943 VSS 0.02581f $ **FLOATING
C1641 IOVDD.n944 VSS 0.02581f $ **FLOATING
C1642 IOVDD.n945 VSS 0.02581f $ **FLOATING
C1643 IOVDD.n946 VSS 0.02581f $ **FLOATING
C1644 IOVDD.t112 VSS 0.01863f $ **FLOATING
C1645 IOVDD.n947 VSS 0.08455f $ **FLOATING
C1646 IOVDD.n948 VSS 0.07206f $ **FLOATING
C1647 IOVDD.n950 VSS 0.01118f $ **FLOATING
C1648 IOVDD.n951 VSS 0.35936f $ **FLOATING
C1649 IOVDD.n960 VSS 0.01839f $ **FLOATING
C1650 IOVDD.n962 VSS 0.56325f $ **FLOATING
C1651 IOVDD.t83 VSS 0.09317f $ **FLOATING
C1652 IOVDD.n963 VSS 0.01933f $ **FLOATING
C1653 IOVDD.n964 VSS 0.02085f $ **FLOATING
C1654 IOVDD.n965 VSS 0.0185f $ **FLOATING
C1655 IOVDD.n966 VSS 0.03328f $ **FLOATING
C1656 IOVDD.n967 VSS 0.01905f $ **FLOATING
C1657 IOVDD.t27 VSS 0.10413f $ **FLOATING
C1658 IOVDD.n968 VSS 0.03425f $ **FLOATING
C1659 IOVDD.n969 VSS 0.03269f $ **FLOATING
C1660 IOVDD.n970 VSS 0.01933f $ **FLOATING
C1661 IOVDD.n971 VSS 0.01877f $ **FLOATING
C1662 IOVDD.n972 VSS 0.01905f $ **FLOATING
C1663 IOVDD.n973 VSS 0.01877f $ **FLOATING
C1664 IOVDD.n974 VSS 0.01905f $ **FLOATING
C1665 IOVDD.n975 VSS 0.01877f $ **FLOATING
C1666 IOVDD.n976 VSS 0.01933f $ **FLOATING
C1667 IOVDD.n977 VSS 0.01877f $ **FLOATING
C1668 IOVDD.n978 VSS 0.01905f $ **FLOATING
C1669 IOVDD.n979 VSS 0.01877f $ **FLOATING
C1670 IOVDD.n980 VSS 0.01905f $ **FLOATING
C1671 IOVDD.n981 VSS 0.01877f $ **FLOATING
C1672 IOVDD.n982 VSS 0.01905f $ **FLOATING
C1673 IOVDD.n983 VSS 0.01877f $ **FLOATING
C1674 IOVDD.n984 VSS 0.01933f $ **FLOATING
C1675 IOVDD.n985 VSS 0.01877f $ **FLOATING
C1676 IOVDD.n986 VSS 0.01905f $ **FLOATING
C1677 IOVDD.n987 VSS 0.01877f $ **FLOATING
C1678 IOVDD.n988 VSS 0.01905f $ **FLOATING
C1679 IOVDD.n989 VSS 0.01877f $ **FLOATING
C1680 IOVDD.n990 VSS 0.01933f $ **FLOATING
C1681 IOVDD.n991 VSS 0.03733f $ **FLOATING
C1682 IOVDD.n993 VSS 0.03755f $ **FLOATING
C1683 IOVDD.n994 VSS 0.01905f $ **FLOATING
C1684 IOVDD.n995 VSS 0.01877f $ **FLOATING
C1685 IOVDD.n996 VSS 0.01905f $ **FLOATING
C1686 IOVDD.n997 VSS 0.01988f $ **FLOATING
C1687 IOVDD.n999 VSS 0.0381f $ **FLOATING
C1688 IOVDD.n1001 VSS 0.03733f $ **FLOATING
C1689 IOVDD.n1002 VSS 0.01905f $ **FLOATING
C1690 IOVDD.n1003 VSS 0.01877f $ **FLOATING
C1691 IOVDD.n1004 VSS 0.01933f $ **FLOATING
C1692 IOVDD.n1005 VSS 0.01877f $ **FLOATING
C1693 IOVDD.n1006 VSS 0.01905f $ **FLOATING
C1694 IOVDD.n1007 VSS 0.01877f $ **FLOATING
C1695 IOVDD.n1008 VSS 0.01905f $ **FLOATING
C1696 IOVDD.n1009 VSS 0.01877f $ **FLOATING
C1697 IOVDD.n1010 VSS 0.01905f $ **FLOATING
C1698 IOVDD.n1011 VSS 0.01877f $ **FLOATING
C1699 IOVDD.n1012 VSS 0.01933f $ **FLOATING
C1700 IOVDD.n1013 VSS 0.01877f $ **FLOATING
C1701 IOVDD.n1014 VSS 0.01905f $ **FLOATING
C1702 IOVDD.n1015 VSS 0.01877f $ **FLOATING
C1703 IOVDD.n1016 VSS 0.01905f $ **FLOATING
C1704 IOVDD.n1017 VSS 0.01877f $ **FLOATING
C1705 IOVDD.n1018 VSS 0.01933f $ **FLOATING
C1706 IOVDD.n1019 VSS 0.01877f $ **FLOATING
C1707 IOVDD.n1020 VSS 0.01905f $ **FLOATING
C1708 IOVDD.n1021 VSS 0.01877f $ **FLOATING
C1709 IOVDD.n1022 VSS 0.01905f $ **FLOATING
C1710 IOVDD.n1023 VSS 0.01877f $ **FLOATING
C1711 IOVDD.t169 VSS 0.09317f $ **FLOATING
C1712 IOVDD.n1024 VSS 0.01877f $ **FLOATING
C1713 IOVDD.n1025 VSS 0.03203f $ **FLOATING
C1714 IOVDD.n1026 VSS 0.01877f $ **FLOATING
C1715 IOVDD.n1027 VSS 0.01877f $ **FLOATING
C1716 IOVDD.t7 VSS 0.10413f $ **FLOATING
C1717 IOVDD.n1028 VSS 0.01933f $ **FLOATING
C1718 IOVDD.n1029 VSS 0.01877f $ **FLOATING
C1719 IOVDD.n1030 VSS 0.01905f $ **FLOATING
C1720 IOVDD.n1031 VSS 0.01877f $ **FLOATING
C1721 IOVDD.n1032 VSS 0.01905f $ **FLOATING
C1722 IOVDD.n1033 VSS 0.01877f $ **FLOATING
C1723 IOVDD.n1034 VSS 0.01933f $ **FLOATING
C1724 IOVDD.n1035 VSS 0.01877f $ **FLOATING
C1725 IOVDD.n1036 VSS 0.01905f $ **FLOATING
C1726 IOVDD.n1037 VSS 0.01877f $ **FLOATING
C1727 IOVDD.n1038 VSS 0.01905f $ **FLOATING
C1728 IOVDD.n1039 VSS 0.01877f $ **FLOATING
C1729 IOVDD.n1040 VSS 0.01905f $ **FLOATING
C1730 IOVDD.n1041 VSS 0.01877f $ **FLOATING
C1731 IOVDD.n1042 VSS 0.01933f $ **FLOATING
C1732 IOVDD.n1043 VSS 0.01877f $ **FLOATING
C1733 IOVDD.n1044 VSS 0.01905f $ **FLOATING
C1734 IOVDD.n1045 VSS 0.01877f $ **FLOATING
C1735 IOVDD.n1046 VSS 0.01905f $ **FLOATING
C1736 IOVDD.n1047 VSS 0.01877f $ **FLOATING
C1737 IOVDD.n1048 VSS 0.01933f $ **FLOATING
C1738 IOVDD.n1049 VSS 0.01877f $ **FLOATING
C1739 IOVDD.n1050 VSS 0.01905f $ **FLOATING
C1740 IOVDD.n1051 VSS 0.03755f $ **FLOATING
C1741 IOVDD.n1053 VSS 0.03733f $ **FLOATING
C1742 IOVDD.n1054 VSS 0.01905f $ **FLOATING
C1743 IOVDD.n1055 VSS 0.01877f $ **FLOATING
C1744 IOVDD.n1056 VSS 0.01933f $ **FLOATING
C1745 IOVDD.n1057 VSS 0.01877f $ **FLOATING
C1746 IOVDD.n1058 VSS 0.01905f $ **FLOATING
C1747 IOVDD.n1059 VSS 0.01877f $ **FLOATING
C1748 IOVDD.n1060 VSS 0.01905f $ **FLOATING
C1749 IOVDD.n1061 VSS 0.01877f $ **FLOATING
C1750 IOVDD.n1062 VSS 0.01933f $ **FLOATING
C1751 IOVDD.n1063 VSS 0.01877f $ **FLOATING
C1752 IOVDD.n1064 VSS 0.01905f $ **FLOATING
C1753 IOVDD.n1065 VSS 0.01877f $ **FLOATING
C1754 IOVDD.n1066 VSS 0.01905f $ **FLOATING
C1755 IOVDD.n1067 VSS 0.01877f $ **FLOATING
C1756 IOVDD.n1068 VSS 0.01905f $ **FLOATING
C1757 IOVDD.n1069 VSS 0.01877f $ **FLOATING
C1758 IOVDD.n1070 VSS 0.01933f $ **FLOATING
C1759 IOVDD.n1071 VSS 0.01877f $ **FLOATING
C1760 IOVDD.n1072 VSS 0.01905f $ **FLOATING
C1761 IOVDD.n1073 VSS 0.01877f $ **FLOATING
C1762 IOVDD.n1074 VSS 0.01905f $ **FLOATING
C1763 IOVDD.n1075 VSS 0.01877f $ **FLOATING
C1764 IOVDD.n1076 VSS 0.01933f $ **FLOATING
C1765 IOVDD.n1077 VSS 0.01877f $ **FLOATING
C1766 IOVDD.n1078 VSS 0.01905f $ **FLOATING
C1767 IOVDD.n1079 VSS 0.01877f $ **FLOATING
C1768 IOVDD.n1080 VSS 0.01905f $ **FLOATING
C1769 IOVDD.n1081 VSS 0.01877f $ **FLOATING
C1770 IOVDD.n1082 VSS 0.01905f $ **FLOATING
C1771 IOVDD.n1083 VSS 0.07175f $ **FLOATING
C1772 IOVDD.n1084 VSS 0.02223f $ **FLOATING
C1773 IOVDD.n1085 VSS 0.01579f $ **FLOATING
C1774 IOVDD.n1086 VSS 0.05665f $ **FLOATING
C1775 IOVDD.t16 VSS 0.10428f $ **FLOATING
C1776 IOVDD.t10 VSS 0.10428f $ **FLOATING
C1777 IOVDD.t11 VSS 0.13628f $ **FLOATING
C1778 IOVDD.n1087 VSS 0.02264f $ **FLOATING
C1779 IOVDD.n1088 VSS 0.01877f $ **FLOATING
C1780 IOVDD.n1089 VSS 0.03693f $ **FLOATING
C1781 IOVDD.n1090 VSS 0.01877f $ **FLOATING
C1782 IOVDD.n1091 VSS 0.01877f $ **FLOATING
C1783 IOVDD.n1092 VSS 0.03269f $ **FLOATING
C1784 IOVDD.n1093 VSS 0.04353f $ **FLOATING
C1785 IOVDD.n1094 VSS 0.01933f $ **FLOATING
C1786 IOVDD.n1095 VSS 0.01905f $ **FLOATING
C1787 IOVDD.n1096 VSS 0.01905f $ **FLOATING
C1788 IOVDD.n1097 VSS 0.01933f $ **FLOATING
C1789 IOVDD.n1098 VSS 0.01905f $ **FLOATING
C1790 IOVDD.n1099 VSS 0.01905f $ **FLOATING
C1791 IOVDD.n1100 VSS 0.01905f $ **FLOATING
C1792 IOVDD.n1101 VSS 0.01933f $ **FLOATING
C1793 IOVDD.n1102 VSS 0.01905f $ **FLOATING
C1794 IOVDD.n1103 VSS 0.01905f $ **FLOATING
C1795 IOVDD.n1104 VSS 0.01933f $ **FLOATING
C1796 IOVDD.n1105 VSS 0.01905f $ **FLOATING
C1797 IOVDD.n1106 VSS 0.01905f $ **FLOATING
C1798 IOVDD.n1107 VSS 0.01905f $ **FLOATING
C1799 IOVDD.n1109 VSS 0.01905f $ **FLOATING
C1800 IOVDD.n1110 VSS 0.01905f $ **FLOATING
C1801 IOVDD.n1111 VSS 0.01933f $ **FLOATING
C1802 IOVDD.n1112 VSS 0.01905f $ **FLOATING
C1803 IOVDD.n1113 VSS 0.01905f $ **FLOATING
C1804 IOVDD.n1114 VSS 0.01905f $ **FLOATING
C1805 IOVDD.n1115 VSS 0.01933f $ **FLOATING
C1806 IOVDD.n1116 VSS 0.01905f $ **FLOATING
C1807 IOVDD.n1117 VSS 0.01905f $ **FLOATING
C1808 IOVDD.n1118 VSS 0.01933f $ **FLOATING
C1809 IOVDD.n1119 VSS 0.01905f $ **FLOATING
C1810 IOVDD.n1120 VSS 0.01905f $ **FLOATING
C1811 IOVDD.n1121 VSS 0.01877f $ **FLOATING
C1812 IOVDD.t20 VSS 0.10413f $ **FLOATING
C1813 IOVDD.n1122 VSS 0.04633f $ **FLOATING
C1814 IOVDD.n1123 VSS 0.01877f $ **FLOATING
C1815 IOVDD.n1124 VSS 0.01877f $ **FLOATING
C1816 IOVDD.n1125 VSS 0.01877f $ **FLOATING
C1817 IOVDD.n1126 VSS 0.01877f $ **FLOATING
C1818 IOVDD.n1127 VSS 0.01877f $ **FLOATING
C1819 IOVDD.n1128 VSS 0.01877f $ **FLOATING
C1820 IOVDD.n1129 VSS 0.03713f $ **FLOATING
C1821 IOVDD.n1130 VSS 0.01877f $ **FLOATING
C1822 IOVDD.n1131 VSS 0.01877f $ **FLOATING
C1823 IOVDD.n1132 VSS 0.01877f $ **FLOATING
C1824 IOVDD.n1133 VSS 0.01877f $ **FLOATING
C1825 IOVDD.n1134 VSS 0.01877f $ **FLOATING
C1826 IOVDD.n1135 VSS 0.01877f $ **FLOATING
C1827 IOVDD.n1136 VSS 0.01877f $ **FLOATING
C1828 IOVDD.n1137 VSS 0.01877f $ **FLOATING
C1829 IOVDD.n1138 VSS 0.01877f $ **FLOATING
C1830 IOVDD.n1139 VSS 0.01877f $ **FLOATING
C1831 IOVDD.n1140 VSS 0.01877f $ **FLOATING
C1832 IOVDD.n1141 VSS 0.03755f $ **FLOATING
C1833 IOVDD.n1142 VSS 0.01877f $ **FLOATING
C1834 IOVDD.n1143 VSS 0.01877f $ **FLOATING
C1835 IOVDD.n1144 VSS 0.01877f $ **FLOATING
C1836 IOVDD.n1145 VSS 0.01877f $ **FLOATING
C1837 IOVDD.n1146 VSS 0.01877f $ **FLOATING
C1838 IOVDD.n1147 VSS 0.01877f $ **FLOATING
C1839 IOVDD.n1148 VSS 0.01877f $ **FLOATING
C1840 IOVDD.t148 VSS 0.09317f $ **FLOATING
C1841 IOVDD.n1149 VSS 0.01877f $ **FLOATING
C1842 IOVDD.n1150 VSS 0.01905f $ **FLOATING
C1843 IOVDD.n1151 VSS 0.02066f $ **FLOATING
C1844 IOVDD.n1152 VSS 0.01933f $ **FLOATING
C1845 IOVDD.n1153 VSS 0.01905f $ **FLOATING
C1846 IOVDD.n1154 VSS 0.01905f $ **FLOATING
C1847 IOVDD.n1155 VSS 0.01933f $ **FLOATING
C1848 IOVDD.n1156 VSS 0.01905f $ **FLOATING
C1849 IOVDD.n1157 VSS 0.01905f $ **FLOATING
C1850 IOVDD.n1158 VSS 0.01905f $ **FLOATING
C1851 IOVDD.n1159 VSS 0.01933f $ **FLOATING
C1852 IOVDD.n1160 VSS 0.01905f $ **FLOATING
C1853 IOVDD.n1161 VSS 0.01905f $ **FLOATING
C1854 IOVDD.n1162 VSS 0.01933f $ **FLOATING
C1855 IOVDD.n1164 VSS 0.01905f $ **FLOATING
C1856 IOVDD.n1165 VSS 0.01905f $ **FLOATING
C1857 IOVDD.n1167 VSS 0.01905f $ **FLOATING
C1858 IOVDD.n1168 VSS 0.01933f $ **FLOATING
C1859 IOVDD.n1169 VSS 0.01905f $ **FLOATING
C1860 IOVDD.n1170 VSS 0.01905f $ **FLOATING
C1861 IOVDD.n1171 VSS 0.01905f $ **FLOATING
C1862 IOVDD.n1172 VSS 0.01933f $ **FLOATING
C1863 IOVDD.n1173 VSS 0.01905f $ **FLOATING
C1864 IOVDD.n1174 VSS 0.01905f $ **FLOATING
C1865 IOVDD.n1175 VSS 0.01933f $ **FLOATING
C1866 IOVDD.n1176 VSS 0.01905f $ **FLOATING
C1867 IOVDD.n1177 VSS 0.01905f $ **FLOATING
C1868 IOVDD.n1178 VSS 0.01905f $ **FLOATING
C1869 IOVDD.t6 VSS 0.10413f $ **FLOATING
C1870 IOVDD.n1179 VSS 0.03269f $ **FLOATING
C1871 IOVDD.n1180 VSS 0.01877f $ **FLOATING
C1872 IOVDD.n1181 VSS 0.01877f $ **FLOATING
C1873 IOVDD.n1182 VSS 0.01877f $ **FLOATING
C1874 IOVDD.n1183 VSS 0.01877f $ **FLOATING
C1875 IOVDD.n1184 VSS 0.01877f $ **FLOATING
C1876 IOVDD.n1185 VSS 0.01877f $ **FLOATING
C1877 IOVDD.n1186 VSS 0.01877f $ **FLOATING
C1878 IOVDD.n1187 VSS 0.01877f $ **FLOATING
C1879 IOVDD.n1188 VSS 0.01877f $ **FLOATING
C1880 IOVDD.n1189 VSS 0.01877f $ **FLOATING
C1881 IOVDD.n1190 VSS 0.03733f $ **FLOATING
C1882 IOVDD.n1191 VSS 0.03755f $ **FLOATING
C1883 IOVDD.n1192 VSS 0.01877f $ **FLOATING
C1884 IOVDD.n1193 VSS 0.01988f $ **FLOATING
C1885 IOVDD.n1195 VSS 0.0381f $ **FLOATING
C1886 IOVDD.n1196 VSS 0.03733f $ **FLOATING
C1887 IOVDD.n1197 VSS 0.01877f $ **FLOATING
C1888 IOVDD.n1198 VSS 0.01877f $ **FLOATING
C1889 IOVDD.n1199 VSS 0.01877f $ **FLOATING
C1890 IOVDD.n1200 VSS 0.01877f $ **FLOATING
C1891 IOVDD.n1201 VSS 0.01877f $ **FLOATING
C1892 IOVDD.n1202 VSS 0.01877f $ **FLOATING
C1893 IOVDD.n1203 VSS 0.01877f $ **FLOATING
C1894 IOVDD.n1204 VSS 0.01877f $ **FLOATING
C1895 IOVDD.n1205 VSS 0.01877f $ **FLOATING
C1896 IOVDD.n1206 VSS 0.01877f $ **FLOATING
C1897 IOVDD.n1207 VSS 0.01877f $ **FLOATING
C1898 IOVDD.t88 VSS 0.09317f $ **FLOATING
C1899 IOVDD.n1208 VSS 0.01877f $ **FLOATING
C1900 IOVDD.n1209 VSS 0.03203f $ **FLOATING
C1901 IOVDD.n1210 VSS 0.01933f $ **FLOATING
C1902 IOVDD.n1211 VSS 0.01905f $ **FLOATING
C1903 IOVDD.n1212 VSS 0.01905f $ **FLOATING
C1904 IOVDD.n1213 VSS 0.01933f $ **FLOATING
C1905 IOVDD.n1214 VSS 0.01905f $ **FLOATING
C1906 IOVDD.n1215 VSS 0.01905f $ **FLOATING
C1907 IOVDD.n1216 VSS 0.01905f $ **FLOATING
C1908 IOVDD.n1217 VSS 0.01933f $ **FLOATING
C1909 IOVDD.n1218 VSS 0.01905f $ **FLOATING
C1910 IOVDD.n1219 VSS 0.01905f $ **FLOATING
C1911 IOVDD.n1220 VSS 0.01933f $ **FLOATING
C1912 IOVDD.n1222 VSS 0.01905f $ **FLOATING
C1913 IOVDD.n1223 VSS 0.01905f $ **FLOATING
C1914 IOVDD.n1224 VSS 0.01933f $ **FLOATING
C1915 IOVDD.n1225 VSS 0.01905f $ **FLOATING
C1916 IOVDD.n1226 VSS 0.01905f $ **FLOATING
C1917 IOVDD.n1227 VSS 0.01933f $ **FLOATING
C1918 IOVDD.n1228 VSS 0.01905f $ **FLOATING
C1919 IOVDD.n1229 VSS 0.01905f $ **FLOATING
C1920 IOVDD.n1230 VSS 0.01905f $ **FLOATING
C1921 IOVDD.n1231 VSS 0.01933f $ **FLOATING
C1922 IOVDD.n1232 VSS 0.01905f $ **FLOATING
C1923 IOVDD.n1233 VSS 0.01905f $ **FLOATING
C1924 IOVDD.n1234 VSS 0.01933f $ **FLOATING
C1925 IOVDD.n1235 VSS 0.01905f $ **FLOATING
C1926 IOVDD.n1236 VSS 0.01905f $ **FLOATING
C1927 IOVDD.n1237 VSS 0.01905f $ **FLOATING
C1928 IOVDD.t8 VSS 0.10413f $ **FLOATING
C1929 IOVDD.n1239 VSS 0.01877f $ **FLOATING
C1930 IOVDD.n1240 VSS 0.01877f $ **FLOATING
C1931 IOVDD.n1241 VSS 0.01877f $ **FLOATING
C1932 IOVDD.n1242 VSS 0.01877f $ **FLOATING
C1933 IOVDD.n1243 VSS 0.01877f $ **FLOATING
C1934 IOVDD.n1244 VSS 0.01877f $ **FLOATING
C1935 IOVDD.n1245 VSS 0.01877f $ **FLOATING
C1936 IOVDD.n1246 VSS 0.01877f $ **FLOATING
C1937 IOVDD.n1247 VSS 0.01877f $ **FLOATING
C1938 IOVDD.n1248 VSS 0.01877f $ **FLOATING
C1939 IOVDD.n1249 VSS 0.03733f $ **FLOATING
C1940 IOVDD.n1250 VSS 0.03755f $ **FLOATING
C1941 IOVDD.n1251 VSS 0.01877f $ **FLOATING
C1942 IOVDD.n1252 VSS 0.01877f $ **FLOATING
C1943 IOVDD.n1253 VSS 0.01877f $ **FLOATING
C1944 IOVDD.n1254 VSS 0.01877f $ **FLOATING
C1945 IOVDD.n1255 VSS 0.01877f $ **FLOATING
C1946 IOVDD.n1256 VSS 0.01877f $ **FLOATING
C1947 IOVDD.n1257 VSS 0.01877f $ **FLOATING
C1948 IOVDD.n1258 VSS 0.01877f $ **FLOATING
C1949 IOVDD.n1259 VSS 0.01877f $ **FLOATING
C1950 IOVDD.n1260 VSS 0.01877f $ **FLOATING
C1951 IOVDD.n1261 VSS 0.01877f $ **FLOATING
C1952 IOVDD.n1262 VSS 0.01877f $ **FLOATING
C1953 IOVDD.n1263 VSS 0.01877f $ **FLOATING
C1954 IOVDD.n1264 VSS 0.01877f $ **FLOATING
C1955 IOVDD.n1265 VSS 0.01877f $ **FLOATING
C1956 IOVDD.t107 VSS 0.09317f $ **FLOATING
C1957 IOVDD.n1266 VSS 0.01877f $ **FLOATING
C1958 IOVDD.n1267 VSS 0.01822f $ **FLOATING
C1959 IOVDD.n1268 VSS 0.04885f $ **FLOATING
C1960 IOVDD.n1269 VSS 0.01983f $ **FLOATING
C1961 IOVDD.n1270 VSS 0.01956f $ **FLOATING
C1962 IOVDD.n1271 VSS 0.01956f $ **FLOATING
C1963 IOVDD.n1272 VSS 0.01983f $ **FLOATING
C1964 IOVDD.n1273 VSS 0.01956f $ **FLOATING
C1965 IOVDD.n1274 VSS 0.01956f $ **FLOATING
C1966 IOVDD.n1275 VSS 0.01983f $ **FLOATING
C1967 IOVDD.n1276 VSS 0.01956f $ **FLOATING
C1968 IOVDD.n1277 VSS 0.01956f $ **FLOATING
C1969 IOVDD.n1278 VSS 0.01983f $ **FLOATING
C1970 IOVDD.n1279 VSS 0.01956f $ **FLOATING
C1971 IOVDD.n1280 VSS 0.01956f $ **FLOATING
C1972 IOVDD.n1281 VSS 0.01956f $ **FLOATING
C1973 IOVDD.t171 VSS 0.04658f $ **FLOATING
C1974 IOVDD.n1282 VSS 0.0902f $ **FLOATING
C1975 IOVDD.n1283 VSS 0.01847f $ **FLOATING
C1976 IOVDD.n1284 VSS 0.01847f $ **FLOATING
C1977 IOVDD.n1285 VSS 0.01847f $ **FLOATING
C1978 IOVDD.n1286 VSS 0.01847f $ **FLOATING
C1979 IOVDD.n1287 VSS 0.01847f $ **FLOATING
C1980 IOVDD.n1288 VSS 0.01847f $ **FLOATING
C1981 IOVDD.n1289 VSS 0.01847f $ **FLOATING
C1982 IOVDD.n1290 VSS 0.01847f $ **FLOATING
C1983 IOVDD.n1291 VSS 0.01847f $ **FLOATING
C1984 IOVDD.n1292 VSS 0.01847f $ **FLOATING
C1985 IOVDD.n1293 VSS 0.01847f $ **FLOATING
C1986 IOVDD.n1294 VSS 0.01847f $ **FLOATING
C1987 IOVDD.t172 VSS 0.04658f $ **FLOATING
C1988 IOVDD.n1295 VSS 0.03564f $ **FLOATING
C1989 IOVDD.n1296 VSS 0.02304f $ **FLOATING
C1990 IOVDD.n1297 VSS 0.01847f $ **FLOATING
C1991 IOVDD.n1298 VSS 0.01847f $ **FLOATING
C1992 IOVDD.n1299 VSS 0.03204f $ **FLOATING
C1993 IOVDD.n1300 VSS 0.0326f $ **FLOATING
C1994 IOVDD.t97 VSS 0.62068f $ **FLOATING
C1995 IOVDD.n1301 VSS 0.01847f $ **FLOATING
C1996 IOVDD.n1302 VSS 0.03558f $ **FLOATING
C1997 IOVDD.n1304 VSS 0.01956f $ **FLOATING
C1998 IOVDD.n1305 VSS 0.01956f $ **FLOATING
C1999 IOVDD.n1306 VSS 0.01983f $ **FLOATING
C2000 IOVDD.n1307 VSS 0.01956f $ **FLOATING
C2001 IOVDD.n1308 VSS 0.01956f $ **FLOATING
C2002 IOVDD.n1309 VSS 0.01983f $ **FLOATING
C2003 IOVDD.n1310 VSS 0.01956f $ **FLOATING
C2004 IOVDD.n1311 VSS 0.01956f $ **FLOATING
C2005 IOVDD.n1312 VSS 0.01983f $ **FLOATING
C2006 IOVDD.n1313 VSS 0.01956f $ **FLOATING
C2007 IOVDD.n1314 VSS 0.01956f $ **FLOATING
C2008 IOVDD.n1315 VSS 0.01956f $ **FLOATING
C2009 IOVDD.t98 VSS 0.04658f $ **FLOATING
C2010 IOVDD.n1316 VSS 0.03652f $ **FLOATING
C2011 IOVDD.n1317 VSS 0.03633f $ **FLOATING
C2012 IOVDD.n1318 VSS 0.01847f $ **FLOATING
C2013 IOVDD.n1319 VSS 0.01847f $ **FLOATING
C2014 IOVDD.n1320 VSS 0.01847f $ **FLOATING
C2015 IOVDD.n1321 VSS 0.01847f $ **FLOATING
C2016 IOVDD.n1322 VSS 0.01847f $ **FLOATING
C2017 IOVDD.n1323 VSS 0.01847f $ **FLOATING
C2018 IOVDD.n1324 VSS 0.01847f $ **FLOATING
C2019 IOVDD.n1325 VSS 0.01847f $ **FLOATING
C2020 IOVDD.n1326 VSS 0.01847f $ **FLOATING
C2021 IOVDD.n1327 VSS 0.01847f $ **FLOATING
C2022 IOVDD.n1328 VSS 0.01847f $ **FLOATING
C2023 IOVDD.t99 VSS 0.04658f $ **FLOATING
C2024 IOVDD.n1329 VSS 0.19985f $ **FLOATING
C2025 IOVDD.n1330 VSS 0.03078f $ **FLOATING
C2026 IOVDD.n1331 VSS 0.01956f $ **FLOATING
C2027 IOVDD.n1332 VSS 0.01956f $ **FLOATING
C2028 IOVDD.n1333 VSS 0.01956f $ **FLOATING
C2029 IOVDD.n1334 VSS 0.01983f $ **FLOATING
C2030 IOVDD.n1335 VSS 0.01956f $ **FLOATING
C2031 IOVDD.n1336 VSS 0.01956f $ **FLOATING
C2032 IOVDD.n1337 VSS 0.01983f $ **FLOATING
C2033 IOVDD.n1338 VSS 0.01956f $ **FLOATING
C2034 IOVDD.n1339 VSS 0.01956f $ **FLOATING
C2035 IOVDD.n1340 VSS 0.01983f $ **FLOATING
C2036 IOVDD.n1341 VSS 0.01956f $ **FLOATING
C2037 IOVDD.n1342 VSS 0.01956f $ **FLOATING
C2038 IOVDD.t54 VSS 0.04658f $ **FLOATING
C2039 IOVDD.n1344 VSS 0.03633f $ **FLOATING
C2040 IOVDD.n1345 VSS 0.01847f $ **FLOATING
C2041 IOVDD.n1346 VSS 0.01847f $ **FLOATING
C2042 IOVDD.n1347 VSS 0.01847f $ **FLOATING
C2043 IOVDD.n1348 VSS 0.01847f $ **FLOATING
C2044 IOVDD.n1349 VSS 0.01847f $ **FLOATING
C2045 IOVDD.n1350 VSS 0.20018f $ **FLOATING
C2046 IOVDD.n1351 VSS 0.01847f $ **FLOATING
C2047 IOVDD.n1352 VSS 0.01847f $ **FLOATING
C2048 IOVDD.n1353 VSS 0.01847f $ **FLOATING
C2049 IOVDD.n1354 VSS 0.01847f $ **FLOATING
C2050 IOVDD.n1355 VSS 0.01847f $ **FLOATING
C2051 IOVDD.n1356 VSS 0.01847f $ **FLOATING
C2052 IOVDD.t55 VSS 0.04658f $ **FLOATING
C2053 IOVDD.n1357 VSS 0.03652f $ **FLOATING
C2054 IOVDD.n1358 VSS 0.03558f $ **FLOATING
C2055 IOVDD.n1359 VSS 0.01847f $ **FLOATING
C2056 IOVDD.n1360 VSS 0.01847f $ **FLOATING
C2057 IOVDD.n1361 VSS 0.01847f $ **FLOATING
C2058 IOVDD.n1362 VSS 0.0326f $ **FLOATING
C2059 IOVDD.t53 VSS 0.62068f $ **FLOATING
C2060 IOVDD.n1363 VSS 0.03204f $ **FLOATING
C2061 IOVDD.n1364 VSS 0.02304f $ **FLOATING
C2062 IOVDD.n1365 VSS 0.01956f $ **FLOATING
C2063 IOVDD.n1366 VSS 0.01956f $ **FLOATING
C2064 IOVDD.n1367 VSS 0.01956f $ **FLOATING
C2065 IOVDD.n1368 VSS 0.01983f $ **FLOATING
C2066 IOVDD.n1369 VSS 0.01956f $ **FLOATING
C2067 IOVDD.n1370 VSS 0.01956f $ **FLOATING
C2068 IOVDD.n1371 VSS 0.01983f $ **FLOATING
C2069 IOVDD.n1372 VSS 0.01956f $ **FLOATING
C2070 IOVDD.n1373 VSS 0.01956f $ **FLOATING
C2071 IOVDD.n1374 VSS 0.01983f $ **FLOATING
C2072 IOVDD.n1375 VSS 0.01956f $ **FLOATING
C2073 IOVDD.n1376 VSS 0.01956f $ **FLOATING
C2074 IOVDD.n1377 VSS 0.01983f $ **FLOATING
C2075 IOVDD.t132 VSS 0.04658f $ **FLOATING
C2076 IOVDD.n1379 VSS 0.01847f $ **FLOATING
C2077 IOVDD.n1380 VSS 0.01847f $ **FLOATING
C2078 IOVDD.n1381 VSS 0.01847f $ **FLOATING
C2079 IOVDD.n1382 VSS 0.01847f $ **FLOATING
C2080 IOVDD.n1383 VSS 0.01847f $ **FLOATING
C2081 IOVDD.n1384 VSS 0.01847f $ **FLOATING
C2082 IOVDD.n1385 VSS 0.01847f $ **FLOATING
C2083 IOVDD.n1386 VSS 0.01847f $ **FLOATING
C2084 IOVDD.n1387 VSS 0.01847f $ **FLOATING
C2085 IOVDD.n1388 VSS 0.01847f $ **FLOATING
C2086 IOVDD.n1389 VSS 0.01847f $ **FLOATING
C2087 IOVDD.n1390 VSS 0.01847f $ **FLOATING
C2088 IOVDD.n1391 VSS 0.03564f $ **FLOATING
C2089 IOVDD.t133 VSS 0.04658f $ **FLOATING
C2090 IOVDD.n1392 VSS 0.0902f $ **FLOATING
C2091 IOVDD.n1393 VSS 0.0724f $ **FLOATING
C2092 IOVDD.n1394 VSS 0.01336f $ **FLOATING
C2093 IOVDD.n1395 VSS 0.08077f $ **FLOATING
C2094 IOVDD.n1396 VSS 0.08573f $ **FLOATING
C2095 IOVDD.n1397 VSS 0.04885f $ **FLOATING
C2096 IOVDD.n1398 VSS 0.47517f $ **FLOATING
C2097 IOVDD.t3 VSS 24.1154f $ **FLOATING
C2098 IOVDD.n1400 VSS 0.29126f $ **FLOATING
C2099 IOVDD.n1401 VSS 0.02112f $ **FLOATING
C2100 IOVDD.n1402 VSS 0.03674f $ **FLOATING
C2101 IOVDD.t87 VSS 1.76037f $ **FLOATING
C2102 IOVDD.n1403 VSS 0.01049f $ **FLOATING
C2103 IOVDD.n1404 VSS 0.02803f $ **FLOATING
C2104 IOVDD.n1405 VSS 0.04445f $ **FLOATING
C2105 IOVDD.n1406 VSS 0.05155f $ **FLOATING
C2106 IOVDD.n1407 VSS 0.04883f $ **FLOATING
C2107 IOVDD.n1408 VSS 0.15526f $ **FLOATING
C2108 IOVDD.n1409 VSS 0.05387f $ **FLOATING
C2109 IOVDD.n1410 VSS 0.089f $ **FLOATING
C2110 IOVDD.n1411 VSS 0.04205f $ **FLOATING
C2111 IOVDD.n1412 VSS 0.07533f $ **FLOATING
C2112 IOVDD.t38 VSS 0.09317f $ **FLOATING
C2113 IOVDD.n1413 VSS 0.03269f $ **FLOATING
C2114 IOVDD.n1414 VSS 0.02112f $ **FLOATING
C2115 IOVDD.n1415 VSS 0.03674f $ **FLOATING
C2116 IOVDD.t36 VSS 1.76037f $ **FLOATING
C2117 IOVDD.n1417 VSS 0.02236f $ **FLOATING
C2118 IOVDD.n1418 VSS 0.01877f $ **FLOATING
C2119 IOVDD.n1419 VSS 0.01905f $ **FLOATING
C2120 IOVDD.n1420 VSS 0.01877f $ **FLOATING
C2121 IOVDD.n1421 VSS 0.01905f $ **FLOATING
C2122 IOVDD.n1422 VSS 0.01877f $ **FLOATING
C2123 IOVDD.n1423 VSS 0.01905f $ **FLOATING
C2124 IOVDD.n1424 VSS 0.01877f $ **FLOATING
C2125 IOVDD.n1425 VSS 0.01933f $ **FLOATING
C2126 IOVDD.n1426 VSS 0.01877f $ **FLOATING
C2127 IOVDD.n1427 VSS 0.01905f $ **FLOATING
C2128 IOVDD.n1428 VSS 0.01877f $ **FLOATING
C2129 IOVDD.n1429 VSS 0.01905f $ **FLOATING
C2130 IOVDD.n1430 VSS 0.01877f $ **FLOATING
C2131 IOVDD.n1431 VSS 0.01933f $ **FLOATING
C2132 IOVDD.n1432 VSS 0.01877f $ **FLOATING
C2133 IOVDD.n1433 VSS 0.01905f $ **FLOATING
C2134 IOVDD.n1434 VSS 0.01877f $ **FLOATING
C2135 IOVDD.n1435 VSS 0.01905f $ **FLOATING
C2136 IOVDD.n1436 VSS 0.01877f $ **FLOATING
C2137 IOVDD.n1437 VSS 0.01905f $ **FLOATING
C2138 IOVDD.n1438 VSS 0.01877f $ **FLOATING
C2139 IOVDD.n1439 VSS 0.01933f $ **FLOATING
C2140 IOVDD.n1440 VSS 0.01877f $ **FLOATING
C2141 IOVDD.n1441 VSS 0.01905f $ **FLOATING
C2142 IOVDD.n1442 VSS 0.01877f $ **FLOATING
C2143 IOVDD.n1443 VSS 0.01905f $ **FLOATING
C2144 IOVDD.n1444 VSS 0.03755f $ **FLOATING
C2145 IOVDD.n1446 VSS 0.03713f $ **FLOATING
C2146 IOVDD.n1447 VSS 0.01905f $ **FLOATING
C2147 IOVDD.n1448 VSS 0.01877f $ **FLOATING
C2148 IOVDD.n1449 VSS 0.01905f $ **FLOATING
C2149 IOVDD.n1450 VSS 0.01877f $ **FLOATING
C2150 IOVDD.n1451 VSS 0.01905f $ **FLOATING
C2151 IOVDD.n1452 VSS 0.01877f $ **FLOATING
C2152 IOVDD.n1453 VSS 0.01933f $ **FLOATING
C2153 IOVDD.n1454 VSS 0.01877f $ **FLOATING
C2154 IOVDD.n1455 VSS 0.01905f $ **FLOATING
C2155 IOVDD.n1456 VSS 0.01877f $ **FLOATING
C2156 IOVDD.n1457 VSS 0.01905f $ **FLOATING
C2157 IOVDD.n1458 VSS 0.01877f $ **FLOATING
C2158 IOVDD.n1459 VSS 0.01933f $ **FLOATING
C2159 IOVDD.n1460 VSS 0.01877f $ **FLOATING
C2160 IOVDD.n1461 VSS 0.01905f $ **FLOATING
C2161 IOVDD.n1462 VSS 0.01877f $ **FLOATING
C2162 IOVDD.n1463 VSS 0.01905f $ **FLOATING
C2163 IOVDD.n1464 VSS 0.01877f $ **FLOATING
C2164 IOVDD.n1465 VSS 0.01905f $ **FLOATING
C2165 IOVDD.n1466 VSS 0.01877f $ **FLOATING
C2166 IOVDD.n1467 VSS 0.01933f $ **FLOATING
C2167 IOVDD.n1468 VSS 0.01877f $ **FLOATING
C2168 IOVDD.n1469 VSS 0.01905f $ **FLOATING
C2169 IOVDD.n1470 VSS 0.01877f $ **FLOATING
C2170 IOVDD.n1471 VSS 0.01905f $ **FLOATING
C2171 IOVDD.n1472 VSS 0.01877f $ **FLOATING
C2172 IOVDD.t18 VSS 0.10413f $ **FLOATING
C2173 IOVDD.n1473 VSS 0.01877f $ **FLOATING
C2174 IOVDD.n1474 VSS 0.02126f $ **FLOATING
C2175 IOVDD.t207 VSS 0.10413f $ **FLOATING
C2176 IOVDD.t196 VSS 0.10413f $ **FLOATING
C2177 IOVDD.t214 VSS 0.10413f $ **FLOATING
C2178 IOVDD.t209 VSS 0.10413f $ **FLOATING
C2179 IOVDD.t197 VSS 0.10413f $ **FLOATING
C2180 IOVDD.t189 VSS 0.10413f $ **FLOATING
C2181 IOVDD.t191 VSS 0.14945f $ **FLOATING
C2182 IOVDD.n1475 VSS 0.05056f $ **FLOATING
C2183 IOVDD.n1476 VSS 0.04928f $ **FLOATING
C2184 IOVDD.n1477 VSS 0.04928f $ **FLOATING
C2185 IOVDD.n1478 VSS 0.04928f $ **FLOATING
C2186 IOVDD.n1479 VSS 0.04928f $ **FLOATING
C2187 IOVDD.n1480 VSS 0.04169f $ **FLOATING
C2188 IOVDD.t199 VSS 0.10413f $ **FLOATING
C2189 IOVDD.t211 VSS 0.10413f $ **FLOATING
C2190 IOVDD.t204 VSS 0.10413f $ **FLOATING
C2191 IOVDD.t201 VSS 0.10413f $ **FLOATING
C2192 IOVDD.t198 VSS 0.10413f $ **FLOATING
C2193 IOVDD.t190 VSS 0.10413f $ **FLOATING
C2194 IOVDD.t194 VSS 0.14945f $ **FLOATING
C2195 IOVDD.n1481 VSS 0.05056f $ **FLOATING
C2196 IOVDD.n1482 VSS 0.04928f $ **FLOATING
C2197 IOVDD.n1483 VSS 0.04928f $ **FLOATING
C2198 IOVDD.n1484 VSS 0.04928f $ **FLOATING
C2199 IOVDD.n1485 VSS 0.04928f $ **FLOATING
C2200 IOVDD.n1486 VSS 0.03687f $ **FLOATING
C2201 IOVDD.n1487 VSS 0.02735f $ **FLOATING
C2202 IOVDD.t200 VSS 0.10413f $ **FLOATING
C2203 IOVDD.t210 VSS 0.10413f $ **FLOATING
C2204 IOVDD.t203 VSS 0.10413f $ **FLOATING
C2205 IOVDD.t202 VSS 0.10413f $ **FLOATING
C2206 IOVDD.t192 VSS 0.10413f $ **FLOATING
C2207 IOVDD.t195 VSS 0.10413f $ **FLOATING
C2208 IOVDD.t213 VSS 0.14945f $ **FLOATING
C2209 IOVDD.n1488 VSS 0.05056f $ **FLOATING
C2210 IOVDD.n1489 VSS 0.04928f $ **FLOATING
C2211 IOVDD.n1490 VSS 0.04928f $ **FLOATING
C2212 IOVDD.n1491 VSS 0.04928f $ **FLOATING
C2213 IOVDD.n1492 VSS 0.04928f $ **FLOATING
C2214 IOVDD.n1493 VSS 0.03687f $ **FLOATING
C2215 IOVDD.n1494 VSS 0.01775f $ **FLOATING
C2216 IOVDD.t205 VSS 0.09317f $ **FLOATING
C2217 IOVDD.t212 VSS 0.09317f $ **FLOATING
C2218 IOVDD.t208 VSS 0.09317f $ **FLOATING
C2219 IOVDD.t206 VSS 0.09317f $ **FLOATING
C2220 IOVDD.t193 VSS 0.09317f $ **FLOATING
C2221 IOVDD.t215 VSS 0.09317f $ **FLOATING
C2222 IOVDD.t216 VSS 0.13849f $ **FLOATING
C2223 IOVDD.n1495 VSS 0.05056f $ **FLOATING
C2224 IOVDD.n1496 VSS 0.04928f $ **FLOATING
C2225 IOVDD.n1497 VSS 0.04928f $ **FLOATING
C2226 IOVDD.n1498 VSS 0.04928f $ **FLOATING
C2227 IOVDD.n1499 VSS 0.04928f $ **FLOATING
C2228 IOVDD.n1500 VSS 0.03579f $ **FLOATING
C2229 IOVDD.n1501 VSS 0.04671f $ **FLOATING
C2230 IOVDD.n1502 VSS 0.06074f $ **FLOATING
C2231 IOVDD.n1503 VSS 0.02973f $ **FLOATING
C2232 IOVDD.n1504 VSS 0.03981f $ **FLOATING
C2233 IOVDD.n1506 VSS 0.01255f $ **FLOATING
C2234 IOVDD.n1507 VSS 0.15009f $ **FLOATING
C2235 IOVDD.n1508 VSS 0.55247f $ **FLOATING
C2236 IOVDD.n1509 VSS 0.03714f $ **FLOATING
C2237 IOVDD.n1510 VSS 0.0287f $ **FLOATING
C2238 IOVDD.n1511 VSS 0.03839f $ **FLOATING
C2239 IOVDD.n1512 VSS 0.02343f $ **FLOATING
C2240 IOVDD.t61 VSS 0.16628f $ **FLOATING
C2241 IOVDD.n1513 VSS 0.01639f $ **FLOATING
C2242 IOVDD.n1514 VSS 0.0944f $ **FLOATING
C2243 IOVDD.n1515 VSS 0.02426f $ **FLOATING
C2244 IOVDD.n1517 VSS 0.02611f $ **FLOATING
C2245 IOVDD.n1518 VSS 0.04516f $ **FLOATING
C2246 IOVDD.n1519 VSS 0.05015f $ **FLOATING
C2247 IOVDD.n1520 VSS 0.04739f $ **FLOATING
C2248 IOVDD.n1521 VSS 0.03515f $ **FLOATING
C2249 IOVDD.n1524 VSS 0.0143f $ **FLOATING
C2250 IOVDD.n1526 VSS 0.01419f $ **FLOATING
C2251 IOVDD.n1527 VSS 0.0193f $ **FLOATING
C2252 IOVDD.n1529 VSS 0.02009f $ **FLOATING
C2253 IOVDD.n1531 VSS 0.07286f $ **FLOATING
C2254 IOVDD.n1532 VSS 0.0631f $ **FLOATING
C2255 IOVDD.n1533 VSS 0.09341f $ **FLOATING
C2256 IOVDD.n1534 VSS 0.03501f $ **FLOATING
C2257 IOVDD.n1535 VSS 0.04178f $ **FLOATING
C2258 IOVDD.n1536 VSS 0.02701f $ **FLOATING
C2259 IOVDD.n1537 VSS 0.04254f $ **FLOATING
C2260 IOVDD.n1538 VSS 0.03411f $ **FLOATING
C2261 IOVDD.n1539 VSS 0.06411f $ **FLOATING
C2262 IOVDD.n1540 VSS 0.03667f $ **FLOATING
C2263 IOVDD.n1541 VSS 0.04178f $ **FLOATING
C2264 IOVDD.n1542 VSS 0.02343f $ **FLOATING
C2265 IOVDD.n1543 VSS 0.04252f $ **FLOATING
C2266 IOVDD.n1544 VSS 0.03248f $ **FLOATING
C2267 IOVDD.n1545 VSS 0.09344f $ **FLOATING
C2268 IOVDD.n1546 VSS 0.05931f $ **FLOATING
C2269 IOVDD.n1547 VSS 0.47073f $ **FLOATING
C2270 IOVDD.n1548 VSS 0.04522f $ **FLOATING
C2271 IOVDD.n1552 VSS 0.71661f $ **FLOATING
C2272 IOVDD.n1553 VSS 0.14929f $ **FLOATING
C2273 IOVDD.t69 VSS 0.34615f $ **FLOATING
C2274 IOVDD.n1561 VSS 0.01451f $ **FLOATING
C2275 IOVDD.t60 VSS 0.15688f $ **FLOATING
C2276 IOVDD.n1562 VSS 0.01415f $ **FLOATING
C2277 IOVDD.t56 VSS 0.06533f $ **FLOATING
C2278 IOVDD.n1563 VSS 0.04975f $ **FLOATING
C2279 IOVDD.t125 VSS 0.06533f $ **FLOATING
C2280 IOVDD.n1564 VSS 0.12062f $ **FLOATING
C2281 IOVDD.n1565 VSS 0.01213f $ **FLOATING
C2282 IOVDD.n1567 VSS 0.29283f $ **FLOATING
C2283 IOVDD.n1569 VSS 0.09338f $ **FLOATING
C2284 IOVDD.n1570 VSS 0.01965f $ **FLOATING
C2285 IOVDD.n1573 VSS 0.09858f $ **FLOATING
C2286 IOVDD.n1576 VSS 0.19335f $ **FLOATING
C2287 IOVDD.n1577 VSS 0.04598f $ **FLOATING
C2288 IOVDD.n1578 VSS 0.12552f $ **FLOATING
C2289 IOVDD.n1579 VSS 0.10183f $ **FLOATING
C2290 IOVDD.n1580 VSS 0.04738f $ **FLOATING
C2291 IOVDD.n1581 VSS 0.03499f $ **FLOATING
C2292 IOVDD.n1582 VSS 0.02846f $ **FLOATING
C2293 IOVDD.n1583 VSS 0.1179f $ **FLOATING
C2294 IOVDD.n1584 VSS 2.77887f $ **FLOATING
C2295 IOVDD.n1585 VSS 0.03946f $ **FLOATING
C2296 IOVDD.n1586 VSS 0.03499f $ **FLOATING
C2297 IOVDD.n1587 VSS 0.03499f $ **FLOATING
C2298 IOVDD.n1588 VSS 0.04998f $ **FLOATING
C2299 IOVDD.n1589 VSS 0.04998f $ **FLOATING
C2300 IOVDD.n1590 VSS 0.04998f $ **FLOATING
C2301 IOVDD.n1591 VSS 0.03499f $ **FLOATING
C2302 IOVDD.n1592 VSS 0.03499f $ **FLOATING
C2303 IOVDD.n1593 VSS 0.03946f $ **FLOATING
C2304 IOVDD.n1594 VSS 0.03946f $ **FLOATING
C2305 IOVDD.n1595 VSS 0.03946f $ **FLOATING
C2306 IOVDD.n1596 VSS 0.03499f $ **FLOATING
C2307 IOVDD.n1597 VSS 0.03499f $ **FLOATING
C2308 IOVDD.n1598 VSS 0.04504f $ **FLOATING
C2309 IOVDD.n1599 VSS 0.02655f $ **FLOATING
C2310 IOVDD.n1600 VSS 0.04498f $ **FLOATING
C2311 IOVDD.n1601 VSS 0.02809f $ **FLOATING
C2312 IOVDD.n1602 VSS 0.02806f $ **FLOATING
C2313 IOVDD.n1603 VSS 0.73269f $ **FLOATING
C2314 IOVDD.n1604 VSS 0.73269f $ **FLOATING
C2315 IOVDD.n1605 VSS 0.03499f $ **FLOATING
C2316 IOVDD.n1606 VSS 0.03499f $ **FLOATING
C2317 IOVDD.n1607 VSS 0.03946f $ **FLOATING
C2318 IOVDD.n1608 VSS 0.03946f $ **FLOATING
C2319 IOVDD.n1609 VSS 0.03499f $ **FLOATING
C2320 IOVDD.n1610 VSS 0.02825f $ **FLOATING
C2321 IOVDD.n1611 VSS 0.0279f $ **FLOATING
C2322 IOVDD.n1612 VSS 0.12288f $ **FLOATING
C2323 IOVDD.n1614 VSS 0.03499f $ **FLOATING
C2324 IOVDD.n1615 VSS 0.03499f $ **FLOATING
C2325 IOVDD.n1616 VSS 0.03946f $ **FLOATING
C2326 IOVDD.n1617 VSS 0.03946f $ **FLOATING
C2327 IOVDD.n1618 VSS 0.03946f $ **FLOATING
C2328 IOVDD.n1619 VSS 0.03946f $ **FLOATING
C2329 IOVDD.n1620 VSS 0.03499f $ **FLOATING
C2330 IOVDD.n1621 VSS 0.03499f $ **FLOATING
C2331 IOVDD.n1623 VSS 0.03499f $ **FLOATING
C2332 IOVDD.n1624 VSS 0.03499f $ **FLOATING
C2333 IOVDD.n1625 VSS 0.02791f $ **FLOATING
C2334 IOVDD.n1626 VSS 0.02825f $ **FLOATING
C2335 IOVDD.n1627 VSS 1.48921f $ **FLOATING
C2336 IOVDD.n1628 VSS 1.48921f $ **FLOATING
C2337 IOVDD.n1629 VSS 0.03946f $ **FLOATING
C2338 IOVDD.n1630 VSS 0.03499f $ **FLOATING
C2339 IOVDD.n1631 VSS 0.03499f $ **FLOATING
C2340 IOVDD.n1632 VSS 0.03005f $ **FLOATING
C2341 IOVDD.n1633 VSS 0.12239f $ **FLOATING
C2342 IOVDD.n1634 VSS 0.04604f $ **FLOATING
C2343 IOVDD.n1635 VSS 0.03499f $ **FLOATING
C2344 IOVDD.n1636 VSS 0.03499f $ **FLOATING
C2345 IOVDD.n1637 VSS 0.03946f $ **FLOATING
C2346 IOVDD.n1638 VSS 0.03946f $ **FLOATING
C2347 IOVDD.n1639 VSS 0.03946f $ **FLOATING
C2348 IOVDD.n1640 VSS 0.03499f $ **FLOATING
C2349 IOVDD.n1641 VSS 0.03499f $ **FLOATING
C2350 IOVDD.n1642 VSS 0.12206f $ **FLOATING
C2351 IOVDD.n1643 VSS 0.03004f $ **FLOATING
C2352 IOVDD.n1644 VSS 0.40097f $ **FLOATING
C2353 IOVDD.n1645 VSS 0.02825f $ **FLOATING
C2354 IOVDD.n1646 VSS 0.03499f $ **FLOATING
C2355 IOVDD.n1647 VSS 0.03499f $ **FLOATING
C2356 IOVDD.n1648 VSS 0.03946f $ **FLOATING
C2357 IOVDD.n1649 VSS 0.03946f $ **FLOATING
C2358 IOVDD.n1650 VSS 0.03946f $ **FLOATING
C2359 IOVDD.n1651 VSS 0.03499f $ **FLOATING
C2360 IOVDD.n1652 VSS 0.03499f $ **FLOATING
C2361 IOVDD.n1653 VSS 0.03477f $ **FLOATING
C2362 IOVDD.n1654 VSS 0.08907f $ **FLOATING
C2363 IOVDD.n1655 VSS 0.07383f $ **FLOATING
C2364 IOVDD.n1656 VSS 0.0259f $ **FLOATING
C2365 IOVDD.n1657 VSS 0.01515f $ **FLOATING
C2366 IOVDD.n1658 VSS 0.03686f $ **FLOATING
C2367 IOVDD.t174 VSS 0.04658f $ **FLOATING
C2368 IOVDD.n1659 VSS 0.02823f $ **FLOATING
C2369 IOVDD.n1660 VSS 0.01316f $ **FLOATING
C2370 IOVDD.n1661 VSS 0.02462f $ **FLOATING
C2371 IOVDD.t144 VSS 0.29623f $ **FLOATING
C2372 IOVDD.n1662 VSS 0.01868f $ **FLOATING
C2373 IOVDD.n1663 VSS 0.02325f $ **FLOATING
C2374 IOVDD.n1665 VSS 0.02823f $ **FLOATING
C2375 IOVDD.t146 VSS 0.04658f $ **FLOATING
C2376 IOVDD.n1666 VSS 0.10264f $ **FLOATING
C2377 IOVDD.n1667 VSS 0.0225f $ **FLOATING
C2378 IOVDD.n1668 VSS 0.03927f $ **FLOATING
C2379 IOVDD.t9 VSS 0.05207f $ **FLOATING
C2380 IOVDD.n1669 VSS 0.02101f $ **FLOATING
C2381 IOVDD.t15 VSS 0.05207f $ **FLOATING
C2382 IOVDD.n1670 VSS 0.02103f $ **FLOATING
C2383 IOVDD.n1671 VSS 0.02644f $ **FLOATING
C2384 IOVDD.n1674 VSS 0.03026f $ **FLOATING
C2385 IOVDD.t1 VSS 11.1936f $ **FLOATING
C2386 IOVDD.n1677 VSS 0.39427f $ **FLOATING
C2387 VR.n0 VSS 0.02439f $ **FLOATING
C2388 VR.t2 VSS 0.49358f $ **FLOATING
C2389 VR.t9 VSS 0.49341f $ **FLOATING
C2390 VR.n1 VSS 0.41302f $ **FLOATING
C2391 VR.t1 VSS 0.49333f $ **FLOATING
C2392 VR.t3 VSS 0.4935f $ **FLOATING
C2393 VR.n2 VSS 0.41308f $ **FLOATING
C2394 VR.t8 VSS 0.37567f $ **FLOATING
C2395 VR.t5 VSS 0.49358f $ **FLOATING
C2396 VR.t10 VSS 0.49341f $ **FLOATING
C2397 VR.n3 VSS 0.41302f $ **FLOATING
C2398 VR.n4 VSS 0.23625f $ **FLOATING
C2399 VR.n5 VSS 0.10769f $ **FLOATING
C2400 VR.t7 VSS 0.49333f $ **FLOATING
C2401 VR.t6 VSS 0.4935f $ **FLOATING
C2402 VR.n6 VSS 0.41308f $ **FLOATING
C2403 VR.n7 VSS 0.24808f $ **FLOATING
C2404 VR.n8 VSS 0.24808f $ **FLOATING
C2405 VR.t4 VSS 0.37567f $ **FLOATING
C2406 VR.n9 VSS 0.10769f $ **FLOATING
C2407 VR.n10 VSS 0.23611f $ **FLOATING
C2408 VR.t16 VSS 1.04584f $ **FLOATING
C2409 VR.n11 VSS 0.02773f $ **FLOATING
C2410 VR.n12 VSS 0.05281f $ **FLOATING
C2411 VR.t15 VSS 1.1298f $ **FLOATING
C2412 VR.t14 VSS 0.52888f $ **FLOATING
C2413 VR.n13 VSS 0.13311f $ **FLOATING
C2414 VR.t11 VSS 0.48278f $ **FLOATING
C2415 VR.n14 VSS 0.17777f $ **FLOATING
C2416 VR.t13 VSS 0.37579f $ **FLOATING
C2417 VR.t12 VSS 0.51438f $ **FLOATING
C2418 VR.t0 VSS 0.08182f $ **FLOATING
C2419 VR.n15 VSS 0.74028f $ **FLOATING
C2420 VR.n16 VSS 0.18966f $ **FLOATING
C2421 VR.n17 VSS 0.16607f $ **FLOATING
C2422 VR.n18 VSS 0.25667f $ **FLOATING
C2423 ldo_brahim_0.I_Bias.t15 VSS 4.20558f $ **FLOATING
C2424 ldo_brahim_0.I_Bias.n0 VSS 1.17274f $ **FLOATING
C2425 ldo_brahim_0.I_Bias.t1 VSS 3.25474f $ **FLOATING
C2426 ldo_brahim_0.I_Bias.t18 VSS 16.9102f $ **FLOATING
C2427 ldo_brahim_0.I_Bias.n2 VSS 0.18347f $ **FLOATING
C2428 ldo_brahim_0.I_Bias.t16 VSS 20.251f $ **FLOATING
C2429 ldo_brahim_0.I_Bias.t17 VSS 19.9979f $ **FLOATING
C2430 ldo_brahim_0.I_Bias.n3 VSS 0.21377f $ **FLOATING
C2431 ldo_brahim_0.I_Bias.n4 VSS 0.55876f $ **FLOATING
C2432 ldo_brahim_0.I_Bias.n5 VSS 0.43779f $ **FLOATING
C2433 ldo_brahim_0.I_Bias.t3 VSS 3.48902f $ **FLOATING
C2434 ldo_brahim_0.I_Bias.t4 VSS 0.33336f $ **FLOATING
C2435 ldo_brahim_0.I_Bias.n6 VSS 0.11958f $ **FLOATING
C2436 ldo_brahim_0.I_Bias.n7 VSS 0.1327f $ **FLOATING
C2437 ldo_brahim_0.I_Bias.n8 VSS 0.07978f $ **FLOATING
C2438 ldo_brahim_0.I_Bias.n9 VSS 0.04651f $ **FLOATING
C2439 ldo_brahim_0.I_Bias.t2 VSS 0.26373f $ **FLOATING
C2440 ldo_brahim_0.I_Bias.n10 VSS 0.11119f $ **FLOATING
C2441 ldo_brahim_0.I_Bias.n11 VSS 0.09929f $ **FLOATING
C2442 ldo_brahim_0.I_Bias.n12 VSS 0.02431f $ **FLOATING
C2443 ldo_brahim_0.I_Bias.t10 VSS 0.66594f $ **FLOATING
C2444 ldo_brahim_0.I_Bias.t12 VSS 0.52652f $ **FLOATING
C2445 ldo_brahim_0.I_Bias.n13 VSS 0.24069f $ **FLOATING
C2446 ldo_brahim_0.I_Bias.t6 VSS 0.52652f $ **FLOATING
C2447 ldo_brahim_0.I_Bias.t8 VSS 0.69178f $ **FLOATING
C2448 ldo_brahim_0.I_Bias.t9 VSS 0.69154f $ **FLOATING
C2449 ldo_brahim_0.I_Bias.n14 VSS 0.57887f $ **FLOATING
C2450 ldo_brahim_0.I_Bias.t11 VSS 0.52652f $ **FLOATING
C2451 ldo_brahim_0.I_Bias.t14 VSS 0.52652f $ **FLOATING
C2452 ldo_brahim_0.I_Bias.n15 VSS 0.27007f $ **FLOATING
C2453 ldo_brahim_0.I_Bias.n16 VSS 0.24039f $ **FLOATING
C2454 ldo_brahim_0.I_Bias.n17 VSS 0.41569f $ **FLOATING
C2455 ldo_brahim_0.I_Bias.t5 VSS 0.52652f $ **FLOATING
C2456 ldo_brahim_0.I_Bias.n18 VSS 0.24039f $ **FLOATING
C2457 ldo_brahim_0.I_Bias.t13 VSS 0.52652f $ **FLOATING
C2458 ldo_brahim_0.I_Bias.n19 VSS 0.27008f $ **FLOATING
C2459 ldo_brahim_0.I_Bias.n20 VSS 0.24068f $ **FLOATING
C2460 ldo_brahim_0.I_Bias.n21 VSS 0.18867f $ **FLOATING
C2461 ldo_brahim_0.I_Bias.n23 VSS 0.04296f $ **FLOATING
C2462 ldo_brahim_0.I_Bias.t7 VSS 0.66616f $ **FLOATING
C2463 ldo_brahim_0.I_Bias.n24 VSS 0.55113f $ **FLOATING
C2464 ldo_brahim_0.I_Bias.n25 VSS 0.26204f $ **FLOATING
C2465 ldo_brahim_0.I_Bias.n26 VSS 0.21052f $ **FLOATING
C2466 ldo_brahim_0.I_Bias.n27 VSS 0.3245f $ **FLOATING
C2467 ldo_brahim_0.I_Bias.n28 VSS 1.40529f $ **FLOATING
C2468 ldo_brahim_0.I_Bias.t0 VSS 1.17894f $ **FLOATING
C2469 beta_multiplier_0.beta_multiplier_startup_0.beta_multiplier_startup_enable_0.VS1.t1 VSS 0.27306f $ **FLOATING
C2470 beta_multiplier_0.beta_multiplier_startup_0.beta_multiplier_startup_enable_0.VS1.n0 VSS 0.1015f $ **FLOATING
C2471 beta_multiplier_0.beta_multiplier_startup_0.beta_multiplier_startup_enable_0.VS1.t0 VSS 0.16409f $ **FLOATING
C2472 beta_multiplier_0.beta_multiplier_startup_0.beta_multiplier_startup_enable_0.VS1.n1 VSS 0.04251f $ **FLOATING
C2473 beta_multiplier_0.beta_multiplier_startup_0.beta_multiplier_startup_enable_0.VS1.n2 VSS 0.33972f $ **FLOATING
C2474 beta_multiplier_0.beta_multiplier_startup_0.beta_multiplier_startup_enable_0.VS1.t4 VSS 1.99293f $ **FLOATING
C2475 beta_multiplier_0.beta_multiplier_startup_0.beta_multiplier_startup_enable_0.VS1.t5 VSS 2.93861f $ **FLOATING
C2476 beta_multiplier_0.beta_multiplier_startup_0.beta_multiplier_startup_enable_0.VS1.n3 VSS 0.46357f $ **FLOATING
C2477 beta_multiplier_0.beta_multiplier_startup_0.beta_multiplier_startup_enable_0.VS1.t3 VSS 0.46586f $ **FLOATING
C2478 beta_multiplier_0.beta_multiplier_startup_0.beta_multiplier_startup_enable_0.VS1.t2 VSS 0.43954f $ **FLOATING
C2479 beta_multiplier_0.beta_multiplier_startup_0.beta_multiplier_startup_enable_0.VS1.n4 VSS 0.1326f $ **FLOATING
C2480 beta_multiplier_0.beta_multiplier_startup_0.beta_multiplier_startup_enable_0.VS1.n5 VSS 0.33575f $ **FLOATING
C2481 beta_multiplier_0.beta_multiplier_startup_0.beta_multiplier_startup_enable_0.VS1.n6 VSS 0.19221f $ **FLOATING
C2482 beta_multiplier_0.beta_multiplier_startup_0.beta_multiplier_startup_enable_0.VS1.n7 VSS 0.0257f $ **FLOATING
.ends
